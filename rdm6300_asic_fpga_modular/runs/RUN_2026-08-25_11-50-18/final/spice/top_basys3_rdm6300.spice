* NGSPICE file created from top_basys3_rdm6300.ext - technology: sky130A

* Black-box entry subcircuit for sky130_fd_sc_hd__a31o_1 abstract view
.subckt sky130_fd_sc_hd__a31o_1 A1 A2 A3 B1 VGND VNB VPB VPWR X
.ends

* Black-box entry subcircuit for sky130_fd_sc_hd__o21a_1 abstract view
.subckt sky130_fd_sc_hd__o21a_1 A1 A2 B1 VGND VNB VPB VPWR X
.ends

* Black-box entry subcircuit for sky130_fd_sc_hd__xnor2_4 abstract view
.subckt sky130_fd_sc_hd__xnor2_4 A B VGND VNB VPB VPWR Y
.ends

* Black-box entry subcircuit for sky130_fd_sc_hd__mux2_1 abstract view
.subckt sky130_fd_sc_hd__mux2_1 A0 A1 S VGND VNB VPB VPWR X
.ends

* Black-box entry subcircuit for sky130_ef_sc_hd__decap_12 abstract view
.subckt sky130_ef_sc_hd__decap_12 VPWR VGND VPB VNB
.ends

* Black-box entry subcircuit for sky130_fd_sc_hd__a21oi_1 abstract view
.subckt sky130_fd_sc_hd__a21oi_1 A1 A2 B1 VGND VNB VPB VPWR Y
.ends

* Black-box entry subcircuit for sky130_fd_sc_hd__tapvpwrvgnd_1 abstract view
.subckt sky130_fd_sc_hd__tapvpwrvgnd_1 VGND VPWR
.ends

* Black-box entry subcircuit for sky130_fd_sc_hd__dlygate4sd3_1 abstract view
.subckt sky130_fd_sc_hd__dlygate4sd3_1 A VGND VNB VPB VPWR X
.ends

* Black-box entry subcircuit for sky130_fd_sc_hd__decap_8 abstract view
.subckt sky130_fd_sc_hd__decap_8 VGND VNB VPB VPWR
.ends

* Black-box entry subcircuit for sky130_fd_sc_hd__fill_2 abstract view
.subckt sky130_fd_sc_hd__fill_2 VGND VNB VPB VPWR
.ends

* Black-box entry subcircuit for sky130_fd_sc_hd__decap_3 abstract view
.subckt sky130_fd_sc_hd__decap_3 VGND VNB VPB VPWR
.ends

* Black-box entry subcircuit for sky130_fd_sc_hd__decap_4 abstract view
.subckt sky130_fd_sc_hd__decap_4 VGND VNB VPB VPWR
.ends

* Black-box entry subcircuit for sky130_fd_sc_hd__fill_1 abstract view
.subckt sky130_fd_sc_hd__fill_1 VGND VNB VPB VPWR
.ends

* Black-box entry subcircuit for sky130_fd_sc_hd__dfxtp_1 abstract view
.subckt sky130_fd_sc_hd__dfxtp_1 CLK D VGND VNB VPB VPWR Q
.ends

* Black-box entry subcircuit for sky130_fd_sc_hd__nand3b_4 abstract view
.subckt sky130_fd_sc_hd__nand3b_4 A_N B C VGND VNB VPB VPWR Y
.ends

* Black-box entry subcircuit for sky130_fd_sc_hd__inv_2 abstract view
.subckt sky130_fd_sc_hd__inv_2 A VGND VNB VPB VPWR Y
.ends

* Black-box entry subcircuit for sky130_fd_sc_hd__o41a_1 abstract view
.subckt sky130_fd_sc_hd__o41a_1 A1 A2 A3 A4 B1 VGND VNB VPB VPWR X
.ends

* Black-box entry subcircuit for sky130_fd_sc_hd__clkbuf_4 abstract view
.subckt sky130_fd_sc_hd__clkbuf_4 A VGND VNB VPB VPWR X
.ends

* Black-box entry subcircuit for sky130_fd_sc_hd__clkbuf_2 abstract view
.subckt sky130_fd_sc_hd__clkbuf_2 A VGND VNB VPB VPWR X
.ends

* Black-box entry subcircuit for sky130_fd_sc_hd__nand2_1 abstract view
.subckt sky130_fd_sc_hd__nand2_1 A B VGND VNB VPB VPWR Y
.ends

* Black-box entry subcircuit for sky130_fd_sc_hd__decap_6 abstract view
.subckt sky130_fd_sc_hd__decap_6 VGND VNB VPB VPWR
.ends

* Black-box entry subcircuit for sky130_fd_sc_hd__o31a_1 abstract view
.subckt sky130_fd_sc_hd__o31a_1 A1 A2 A3 B1 VGND VNB VPB VPWR X
.ends

* Black-box entry subcircuit for sky130_fd_sc_hd__buf_2 abstract view
.subckt sky130_fd_sc_hd__buf_2 A VGND VNB VPB VPWR X
.ends

* Black-box entry subcircuit for sky130_fd_sc_hd__a221o_1 abstract view
.subckt sky130_fd_sc_hd__a221o_1 A1 A2 B1 B2 C1 VGND VNB VPB VPWR X
.ends

* Black-box entry subcircuit for sky130_fd_sc_hd__dfrtp_1 abstract view
.subckt sky130_fd_sc_hd__dfrtp_1 CLK D RESET_B VGND VNB VPB VPWR Q
.ends

* Black-box entry subcircuit for sky130_fd_sc_hd__mux4_1 abstract view
.subckt sky130_fd_sc_hd__mux4_1 A0 A1 A2 A3 S0 S1 VGND VNB VPB VPWR X
.ends

* Black-box entry subcircuit for sky130_fd_sc_hd__dfrtp_2 abstract view
.subckt sky130_fd_sc_hd__dfrtp_2 CLK D RESET_B VGND VNB VPB VPWR Q
.ends

* Black-box entry subcircuit for sky130_fd_sc_hd__and3_1 abstract view
.subckt sky130_fd_sc_hd__and3_1 A B C VGND VNB VPB VPWR X
.ends

* Black-box entry subcircuit for sky130_fd_sc_hd__nor2_1 abstract view
.subckt sky130_fd_sc_hd__nor2_1 A B VGND VNB VPB VPWR Y
.ends

* Black-box entry subcircuit for sky130_fd_sc_hd__a21bo_1 abstract view
.subckt sky130_fd_sc_hd__a21bo_1 A1 A2 B1_N VGND VNB VPB VPWR X
.ends

* Black-box entry subcircuit for sky130_fd_sc_hd__xor2_1 abstract view
.subckt sky130_fd_sc_hd__xor2_1 A B VGND VNB VPB VPWR X
.ends

* Black-box entry subcircuit for sky130_fd_sc_hd__o22a_1 abstract view
.subckt sky130_fd_sc_hd__o22a_1 A1 A2 B1 B2 VGND VNB VPB VPWR X
.ends

* Black-box entry subcircuit for sky130_fd_sc_hd__xnor2_1 abstract view
.subckt sky130_fd_sc_hd__xnor2_1 A B VGND VNB VPB VPWR Y
.ends

* Black-box entry subcircuit for sky130_fd_sc_hd__or4_1 abstract view
.subckt sky130_fd_sc_hd__or4_1 A B C D VGND VNB VPB VPWR X
.ends

* Black-box entry subcircuit for sky130_fd_sc_hd__clkbuf_16 abstract view
.subckt sky130_fd_sc_hd__clkbuf_16 A VGND VNB VPB VPWR X
.ends

* Black-box entry subcircuit for sky130_fd_sc_hd__a21o_1 abstract view
.subckt sky130_fd_sc_hd__a21o_1 A1 A2 B1 VGND VNB VPB VPWR X
.ends

* Black-box entry subcircuit for sky130_fd_sc_hd__a31oi_1 abstract view
.subckt sky130_fd_sc_hd__a31oi_1 A1 A2 A3 B1 VGND VNB VPB VPWR Y
.ends

* Black-box entry subcircuit for sky130_fd_sc_hd__and4_1 abstract view
.subckt sky130_fd_sc_hd__and4_1 A B C D VGND VNB VPB VPWR X
.ends

* Black-box entry subcircuit for sky130_fd_sc_hd__or2_1 abstract view
.subckt sky130_fd_sc_hd__or2_1 A B VGND VNB VPB VPWR X
.ends

* Black-box entry subcircuit for sky130_fd_sc_hd__nor2_4 abstract view
.subckt sky130_fd_sc_hd__nor2_4 A B VGND VNB VPB VPWR Y
.ends

* Black-box entry subcircuit for sky130_fd_sc_hd__o21ai_1 abstract view
.subckt sky130_fd_sc_hd__o21ai_1 A1 A2 B1 VGND VNB VPB VPWR Y
.ends

* Black-box entry subcircuit for sky130_fd_sc_hd__dfrtp_4 abstract view
.subckt sky130_fd_sc_hd__dfrtp_4 CLK D RESET_B VGND VNB VPB VPWR Q
.ends

* Black-box entry subcircuit for sky130_fd_sc_hd__clkbuf_8 abstract view
.subckt sky130_fd_sc_hd__clkbuf_8 A VGND VNB VPB VPWR X
.ends

* Black-box entry subcircuit for sky130_fd_sc_hd__nor3_2 abstract view
.subckt sky130_fd_sc_hd__nor3_2 A B C VGND VNB VPB VPWR Y
.ends

* Black-box entry subcircuit for sky130_fd_sc_hd__nor3_1 abstract view
.subckt sky130_fd_sc_hd__nor3_1 A B C VGND VNB VPB VPWR Y
.ends

* Black-box entry subcircuit for sky130_fd_sc_hd__nand2b_1 abstract view
.subckt sky130_fd_sc_hd__nand2b_1 A_N B VGND VNB VPB VPWR Y
.ends

* Black-box entry subcircuit for sky130_fd_sc_hd__a22o_1 abstract view
.subckt sky130_fd_sc_hd__a22o_1 A1 A2 B1 B2 VGND VNB VPB VPWR X
.ends

* Black-box entry subcircuit for sky130_fd_sc_hd__nor2_2 abstract view
.subckt sky130_fd_sc_hd__nor2_2 A B VGND VNB VPB VPWR Y
.ends

* Black-box entry subcircuit for sky130_fd_sc_hd__or4b_1 abstract view
.subckt sky130_fd_sc_hd__or4b_1 A B C D_N VGND VNB VPB VPWR X
.ends

* Black-box entry subcircuit for sky130_fd_sc_hd__a21boi_1 abstract view
.subckt sky130_fd_sc_hd__a21boi_1 A1 A2 B1_N VGND VNB VPB VPWR Y
.ends

* Black-box entry subcircuit for sky130_fd_sc_hd__a211o_1 abstract view
.subckt sky130_fd_sc_hd__a211o_1 A1 A2 B1 C1 VGND VNB VPB VPWR X
.ends

* Black-box entry subcircuit for sky130_fd_sc_hd__and2_1 abstract view
.subckt sky130_fd_sc_hd__and2_1 A B VGND VNB VPB VPWR X
.ends

* Black-box entry subcircuit for sky130_fd_sc_hd__xor2_2 abstract view
.subckt sky130_fd_sc_hd__xor2_2 A B VGND VNB VPB VPWR X
.ends

* Black-box entry subcircuit for sky130_fd_sc_hd__nand2_2 abstract view
.subckt sky130_fd_sc_hd__nand2_2 A B VGND VNB VPB VPWR Y
.ends

* Black-box entry subcircuit for sky130_fd_sc_hd__xor2_4 abstract view
.subckt sky130_fd_sc_hd__xor2_4 A B VGND VNB VPB VPWR X
.ends

* Black-box entry subcircuit for sky130_fd_sc_hd__o211a_1 abstract view
.subckt sky130_fd_sc_hd__o211a_1 A1 A2 B1 C1 VGND VNB VPB VPWR X
.ends

* Black-box entry subcircuit for sky130_fd_sc_hd__or2_2 abstract view
.subckt sky130_fd_sc_hd__or2_2 A B VGND VNB VPB VPWR X
.ends

* Black-box entry subcircuit for sky130_fd_sc_hd__or4bb_1 abstract view
.subckt sky130_fd_sc_hd__or4bb_1 A B C_N D_N VGND VNB VPB VPWR X
.ends

* Black-box entry subcircuit for sky130_fd_sc_hd__or3b_1 abstract view
.subckt sky130_fd_sc_hd__or3b_1 A B C_N VGND VNB VPB VPWR X
.ends

* Black-box entry subcircuit for sky130_fd_sc_hd__clkinvlp_4 abstract view
.subckt sky130_fd_sc_hd__clkinvlp_4 A VGND VNB VPB VPWR Y
.ends

* Black-box entry subcircuit for sky130_fd_sc_hd__and4bb_1 abstract view
.subckt sky130_fd_sc_hd__and4bb_1 A_N B_N C D VGND VNB VPB VPWR X
.ends

* Black-box entry subcircuit for sky130_fd_sc_hd__a32o_1 abstract view
.subckt sky130_fd_sc_hd__a32o_1 A1 A2 A3 B1 B2 VGND VNB VPB VPWR X
.ends

* Black-box entry subcircuit for sky130_fd_sc_hd__and2_2 abstract view
.subckt sky130_fd_sc_hd__and2_2 A B VGND VNB VPB VPWR X
.ends

* Black-box entry subcircuit for sky130_fd_sc_hd__xnor2_2 abstract view
.subckt sky130_fd_sc_hd__xnor2_2 A B VGND VNB VPB VPWR Y
.ends

* Black-box entry subcircuit for sky130_fd_sc_hd__a2111o_1 abstract view
.subckt sky130_fd_sc_hd__a2111o_1 A1 A2 B1 C1 D1 VGND VNB VPB VPWR X
.ends

* Black-box entry subcircuit for sky130_fd_sc_hd__clkinv_8 abstract view
.subckt sky130_fd_sc_hd__clkinv_8 A VGND VNB VPB VPWR Y
.ends

* Black-box entry subcircuit for sky130_fd_sc_hd__inv_12 abstract view
.subckt sky130_fd_sc_hd__inv_12 A VGND VNB VPB VPWR Y
.ends

* Black-box entry subcircuit for sky130_fd_sc_hd__a2111oi_1 abstract view
.subckt sky130_fd_sc_hd__a2111oi_1 A1 A2 B1 C1 D1 VGND VNB VPB VPWR Y
.ends

* Black-box entry subcircuit for sky130_fd_sc_hd__inv_6 abstract view
.subckt sky130_fd_sc_hd__inv_6 A VGND VNB VPB VPWR Y
.ends

* Black-box entry subcircuit for sky130_fd_sc_hd__clkinv_4 abstract view
.subckt sky130_fd_sc_hd__clkinv_4 A VGND VNB VPB VPWR Y
.ends

* Black-box entry subcircuit for sky130_fd_sc_hd__bufinv_16 abstract view
.subckt sky130_fd_sc_hd__bufinv_16 A VGND VNB VPB VPWR Y
.ends

* Black-box entry subcircuit for sky130_fd_sc_hd__o311a_1 abstract view
.subckt sky130_fd_sc_hd__o311a_1 A1 A2 A3 B1 C1 VGND VNB VPB VPWR X
.ends

* Black-box entry subcircuit for sky130_fd_sc_hd__o32a_1 abstract view
.subckt sky130_fd_sc_hd__o32a_1 A1 A2 A3 B1 B2 VGND VNB VPB VPWR X
.ends

* Black-box entry subcircuit for sky130_fd_sc_hd__or2_4 abstract view
.subckt sky130_fd_sc_hd__or2_4 A B VGND VNB VPB VPWR X
.ends

* Black-box entry subcircuit for sky130_fd_sc_hd__and2b_1 abstract view
.subckt sky130_fd_sc_hd__and2b_1 A_N B VGND VNB VPB VPWR X
.ends

* Black-box entry subcircuit for sky130_fd_sc_hd__a22o_2 abstract view
.subckt sky130_fd_sc_hd__a22o_2 A1 A2 B1 B2 VGND VNB VPB VPWR X
.ends

* Black-box entry subcircuit for sky130_fd_sc_hd__dfstp_1 abstract view
.subckt sky130_fd_sc_hd__dfstp_1 CLK D SET_B VGND VNB VPB VPWR Q
.ends

* Black-box entry subcircuit for sky130_fd_sc_hd__inv_8 abstract view
.subckt sky130_fd_sc_hd__inv_8 A VGND VNB VPB VPWR Y
.ends

* Black-box entry subcircuit for sky130_fd_sc_hd__nand2b_2 abstract view
.subckt sky130_fd_sc_hd__nand2b_2 A_N B VGND VNB VPB VPWR Y
.ends

* Black-box entry subcircuit for sky130_fd_sc_hd__a211oi_2 abstract view
.subckt sky130_fd_sc_hd__a211oi_2 A1 A2 B1 C1 VGND VNB VPB VPWR Y
.ends

* Black-box entry subcircuit for sky130_fd_sc_hd__o2111a_1 abstract view
.subckt sky130_fd_sc_hd__o2111a_1 A1 A2 B1 C1 D1 VGND VNB VPB VPWR X
.ends

* Black-box entry subcircuit for sky130_fd_sc_hd__a22oi_4 abstract view
.subckt sky130_fd_sc_hd__a22oi_4 A1 A2 B1 B2 VGND VNB VPB VPWR Y
.ends

* Black-box entry subcircuit for sky130_fd_sc_hd__nand3_1 abstract view
.subckt sky130_fd_sc_hd__nand3_1 A B C VGND VNB VPB VPWR Y
.ends

* Black-box entry subcircuit for sky130_fd_sc_hd__mux2_2 abstract view
.subckt sky130_fd_sc_hd__mux2_2 A0 A1 S VGND VNB VPB VPWR X
.ends

* Black-box entry subcircuit for sky130_fd_sc_hd__or3b_2 abstract view
.subckt sky130_fd_sc_hd__or3b_2 A B C_N VGND VNB VPB VPWR X
.ends

* Black-box entry subcircuit for sky130_fd_sc_hd__or3_4 abstract view
.subckt sky130_fd_sc_hd__or3_4 A B C VGND VNB VPB VPWR X
.ends

* Black-box entry subcircuit for sky130_fd_sc_hd__clkinv_2 abstract view
.subckt sky130_fd_sc_hd__clkinv_2 A VGND VNB VPB VPWR Y
.ends

* Black-box entry subcircuit for sky130_fd_sc_hd__or3b_4 abstract view
.subckt sky130_fd_sc_hd__or3b_4 A B C_N VGND VNB VPB VPWR X
.ends

* Black-box entry subcircuit for sky130_fd_sc_hd__and4b_1 abstract view
.subckt sky130_fd_sc_hd__and4b_1 A_N B C D VGND VNB VPB VPWR X
.ends

* Black-box entry subcircuit for sky130_fd_sc_hd__or3_1 abstract view
.subckt sky130_fd_sc_hd__or3_1 A B C VGND VNB VPB VPWR X
.ends

* Black-box entry subcircuit for sky130_fd_sc_hd__buf_1 abstract view
.subckt sky130_fd_sc_hd__buf_1 A VGND VNB VPB VPWR X
.ends

* Black-box entry subcircuit for sky130_fd_sc_hd__clkinv_1 abstract view
.subckt sky130_fd_sc_hd__clkinv_1 A VGND VNB VPB VPWR Y
.ends

* Black-box entry subcircuit for sky130_fd_sc_hd__nand3_4 abstract view
.subckt sky130_fd_sc_hd__nand3_4 A B C VGND VNB VPB VPWR Y
.ends

* Black-box entry subcircuit for sky130_fd_sc_hd__dlymetal6s2s_1 abstract view
.subckt sky130_fd_sc_hd__dlymetal6s2s_1 A VGND VNB VPB VPWR X
.ends

* Black-box entry subcircuit for sky130_fd_sc_hd__buf_4 abstract view
.subckt sky130_fd_sc_hd__buf_4 A VGND VNB VPB VPWR X
.ends

* Black-box entry subcircuit for sky130_fd_sc_hd__a41o_1 abstract view
.subckt sky130_fd_sc_hd__a41o_1 A1 A2 A3 A4 B1 VGND VNB VPB VPWR X
.ends

* Black-box entry subcircuit for sky130_fd_sc_hd__o22a_2 abstract view
.subckt sky130_fd_sc_hd__o22a_2 A1 A2 B1 B2 VGND VNB VPB VPWR X
.ends

* Black-box entry subcircuit for sky130_fd_sc_hd__inv_4 abstract view
.subckt sky130_fd_sc_hd__inv_4 A VGND VNB VPB VPWR Y
.ends

* Black-box entry subcircuit for sky130_fd_sc_hd__nand4_1 abstract view
.subckt sky130_fd_sc_hd__nand4_1 A B C D VGND VNB VPB VPWR Y
.ends

* Black-box entry subcircuit for sky130_fd_sc_hd__o21ai_2 abstract view
.subckt sky130_fd_sc_hd__o21ai_2 A1 A2 B1 VGND VNB VPB VPWR Y
.ends

* Black-box entry subcircuit for sky130_fd_sc_hd__nand2_4 abstract view
.subckt sky130_fd_sc_hd__nand2_4 A B VGND VNB VPB VPWR Y
.ends

* Black-box entry subcircuit for sky130_fd_sc_hd__dfstp_2 abstract view
.subckt sky130_fd_sc_hd__dfstp_2 CLK D SET_B VGND VNB VPB VPWR Q
.ends

* Black-box entry subcircuit for sky130_fd_sc_hd__clkbuf_1 abstract view
.subckt sky130_fd_sc_hd__clkbuf_1 A VGND VNB VPB VPWR X
.ends

* Black-box entry subcircuit for sky130_fd_sc_hd__nor3b_2 abstract view
.subckt sky130_fd_sc_hd__nor3b_2 A B C_N VGND VNB VPB VPWR Y
.ends

* Black-box entry subcircuit for sky130_fd_sc_hd__and4b_4 abstract view
.subckt sky130_fd_sc_hd__and4b_4 A_N B C D VGND VNB VPB VPWR X
.ends

* Black-box entry subcircuit for sky130_fd_sc_hd__o21ba_1 abstract view
.subckt sky130_fd_sc_hd__o21ba_1 A1 A2 B1_N VGND VNB VPB VPWR X
.ends

* Black-box entry subcircuit for sky130_fd_sc_hd__nand2b_4 abstract view
.subckt sky130_fd_sc_hd__nand2b_4 A_N B VGND VNB VPB VPWR Y
.ends

* Black-box entry subcircuit for sky130_fd_sc_hd__dfxtp_2 abstract view
.subckt sky130_fd_sc_hd__dfxtp_2 CLK D VGND VNB VPB VPWR Q
.ends

* Black-box entry subcircuit for sky130_fd_sc_hd__nor3b_1 abstract view
.subckt sky130_fd_sc_hd__nor3b_1 A B C_N VGND VNB VPB VPWR Y
.ends

* Black-box entry subcircuit for sky130_fd_sc_hd__o21bai_1 abstract view
.subckt sky130_fd_sc_hd__o21bai_1 A1 A2 B1_N VGND VNB VPB VPWR Y
.ends

* Black-box entry subcircuit for sky130_fd_sc_hd__a311o_1 abstract view
.subckt sky130_fd_sc_hd__a311o_1 A1 A2 A3 B1 C1 VGND VNB VPB VPWR X
.ends

* Black-box entry subcircuit for sky130_fd_sc_hd__a22oi_1 abstract view
.subckt sky130_fd_sc_hd__a22oi_1 A1 A2 B1 B2 VGND VNB VPB VPWR Y
.ends

* Black-box entry subcircuit for sky130_fd_sc_hd__conb_1 abstract view
.subckt sky130_fd_sc_hd__conb_1 VGND VNB VPB VPWR HI LO
.ends

* Black-box entry subcircuit for sky130_fd_sc_hd__and3b_1 abstract view
.subckt sky130_fd_sc_hd__and3b_1 A_N B C VGND VNB VPB VPWR X
.ends

* Black-box entry subcircuit for sky130_fd_sc_hd__o2bb2a_1 abstract view
.subckt sky130_fd_sc_hd__o2bb2a_1 A1_N A2_N B1 B2 VGND VNB VPB VPWR X
.ends

* Black-box entry subcircuit for sky130_fd_sc_hd__o221a_1 abstract view
.subckt sky130_fd_sc_hd__o221a_1 A1 A2 B1 B2 C1 VGND VNB VPB VPWR X
.ends

* Black-box entry subcircuit for sky130_fd_sc_hd__buf_6 abstract view
.subckt sky130_fd_sc_hd__buf_6 A VGND VNB VPB VPWR X
.ends

* Black-box entry subcircuit for sky130_fd_sc_hd__nor4_1 abstract view
.subckt sky130_fd_sc_hd__nor4_1 A B C D VGND VNB VPB VPWR Y
.ends

* Black-box entry subcircuit for sky130_fd_sc_hd__o21a_2 abstract view
.subckt sky130_fd_sc_hd__o21a_2 A1 A2 B1 VGND VNB VPB VPWR X
.ends

* Black-box entry subcircuit for sky130_fd_sc_hd__and3_2 abstract view
.subckt sky130_fd_sc_hd__and3_2 A B C VGND VNB VPB VPWR X
.ends

* Black-box entry subcircuit for sky130_fd_sc_hd__diode_2 abstract view
.subckt sky130_fd_sc_hd__diode_2 DIODE VGND VNB VPB VPWR
.ends

* Black-box entry subcircuit for sky130_fd_sc_hd__o21ai_4 abstract view
.subckt sky130_fd_sc_hd__o21ai_4 A1 A2 B1 VGND VNB VPB VPWR Y
.ends

* Black-box entry subcircuit for sky130_fd_sc_hd__nor3b_4 abstract view
.subckt sky130_fd_sc_hd__nor3b_4 A B C_N VGND VNB VPB VPWR Y
.ends

.subckt top_basys3_rdm6300 VGND VPWR clk rdm6300_rx_i uart_tx_o
X_3155_ net59 _1577_ _1582_ _1584_ VGND VGND VPWR VPWR _0637_ sky130_fd_sc_hd__a31o_1
X_3086_ net601 _1540_ _1544_ VGND VGND VPWR VPWR _0608_ sky130_fd_sc_hd__o21a_1
X_2106_ _0980_ _0983_ VGND VGND VPWR VPWR _0984_ sky130_fd_sc_hd__xnor2_4
X_2037_ net21 net330 _0957_ VGND VGND VPWR VPWR _0146_ sky130_fd_sc_hd__mux2_1
XFILLER_35_483 VPWR VGND VPWR VGND sky130_ef_sc_hd__decap_12
XFILLER_52_29 VPWR VGND VPWR VGND sky130_ef_sc_hd__decap_12
X_2939_ u_uart_rx.low_count\[0\] _0844_ u_uart_rx.low_count\[1\] VGND VGND VPWR VPWR
+ _1471_ sky130_fd_sc_hd__a21oi_1
XTAP_TAPCELL_ROW_20_389 VGND VPWR sky130_fd_sc_hd__tapvpwrvgnd_1
Xhold362 u_parser.u_packet_encoder.tag_latched\[18\] VGND VGND VPWR VPWR net518 sky130_fd_sc_hd__dlygate4sd3_1
Xhold351 u_parser.u_packet_encoder.tag_latched\[35\] VGND VGND VPWR VPWR net507 sky130_fd_sc_hd__dlygate4sd3_1
Xhold340 u_parser.u_decoder.decoded_payload\[34\] VGND VGND VPWR VPWR net496 sky130_fd_sc_hd__dlygate4sd3_1
XFILLER_77_15 VPWR VGND VPWR VGND sky130_ef_sc_hd__decap_12
Xhold395 _0200_ VGND VGND VPWR VPWR net551 sky130_fd_sc_hd__dlygate4sd3_1
Xhold384 u_parser.u_packet_encoder.crc_latched\[0\] VGND VGND VPWR VPWR net540 sky130_fd_sc_hd__dlygate4sd3_1
Xhold373 u_parser.u_packet_encoder.tag_latched\[28\] VGND VGND VPWR VPWR net529 sky130_fd_sc_hd__dlygate4sd3_1
XFILLER_58_520 VPWR VGND VPWR VGND sky130_ef_sc_hd__decap_12
XFILLER_92_309 VGND VGND VPWR VPWR sky130_fd_sc_hd__decap_8
XFILLER_58_553 VGND VGND VPWR VPWR sky130_fd_sc_hd__fill_2
XFILLER_73_501 VGND VGND VPWR VPWR sky130_fd_sc_hd__decap_3
XTAP_TAPCELL_ROW_56_732 VGND VPWR sky130_fd_sc_hd__tapvpwrvgnd_1
XFILLER_93_69 VPWR VGND VPWR VGND sky130_ef_sc_hd__decap_12
XFILLER_45_258 VGND VGND VPWR VPWR sky130_fd_sc_hd__decap_3
XTAP_TAPCELL_ROW_28_467 VGND VPWR sky130_fd_sc_hd__tapvpwrvgnd_1
XFILLER_41_431 VGND VGND VPWR VPWR sky130_fd_sc_hd__decap_4
XFILLER_60_239 VGND VGND VPWR VPWR sky130_fd_sc_hd__decap_4
XFILLER_13_155 VPWR VGND VPWR VGND sky130_ef_sc_hd__decap_12
XFILLER_13_177 VPWR VGND VPWR VGND sky130_ef_sc_hd__decap_12
XFILLER_5_343 VGND VGND VPWR VPWR sky130_fd_sc_hd__fill_1
XFILLER_3_78 VGND VGND VPWR VPWR sky130_fd_sc_hd__decap_4
XFILLER_76_383 VGND VGND VPWR VPWR sky130_fd_sc_hd__fill_1
XFILLER_64_545 VGND VGND VPWR VPWR sky130_fd_sc_hd__decap_8
X_3773_ clknet_leaf_17_clk _0591_ VGND VGND VPWR VPWR u_rx_fifo.mem\[2\]\[6\] sky130_fd_sc_hd__dfxtp_1
X_2724_ u_parser.u_decoder.index\[1\] net5 u_parser.u_decoder.index\[0\] VGND VGND
+ VPWR VPWR _1375_ sky130_fd_sc_hd__nand3b_4
X_2655_ net488 _1338_ net8 VGND VGND VPWR VPWR _0383_ sky130_fd_sc_hd__mux2_1
X_1606_ u_parser.u_decoder.decoded_checksum_calc\[1\] VGND VGND VPWR VPWR _0676_ sky130_fd_sc_hd__inv_2
X_2586_ u_parser.u_decoder.ascii_buf\[3\]\[0\] u_parser.u_decoder.ascii_buf\[3\]\[1\]
+ u_parser.u_decoder.ascii_buf\[3\]\[2\] u_parser.u_decoder.ascii_buf\[3\]\[3\] _1284_
+ VGND VGND VPWR VPWR _1285_ sky130_fd_sc_hd__o41a_1
Xfanout138 net144 VGND VGND VPWR VPWR net138 sky130_fd_sc_hd__clkbuf_4
Xfanout105 net113 VGND VGND VPWR VPWR net105 sky130_fd_sc_hd__clkbuf_2
Xfanout127 net130 VGND VGND VPWR VPWR net127 sky130_fd_sc_hd__clkbuf_4
Xfanout116 net126 VGND VGND VPWR VPWR net116 sky130_fd_sc_hd__clkbuf_2
Xfanout149 u_rx_fifo.rd_ptr\[1\] VGND VGND VPWR VPWR net149 sky130_fd_sc_hd__clkbuf_4
XFILLER_86_147 VGND VGND VPWR VPWR sky130_fd_sc_hd__fill_1
X_3207_ clknet_leaf_2_clk _0043_ VGND VGND VPWR VPWR u_tx_fifo.mem\[7\]\[6\] sky130_fd_sc_hd__dfxtp_1
XFILLER_74_309 VPWR VGND VPWR VGND sky130_ef_sc_hd__decap_12
X_3138_ _0703_ _1572_ VGND VGND VPWR VPWR _1573_ sky130_fd_sc_hd__nand2_1
XFILLER_27_225 VGND VGND VPWR VPWR sky130_fd_sc_hd__decap_6
X_3069_ _1532_ _1531_ u_uart_rx.sample_div_count\[5\] VGND VGND VPWR VPWR _0603_ sky130_fd_sc_hd__mux2_1
XTAP_TAPCELL_ROW_53_702 VGND VPWR sky130_fd_sc_hd__tapvpwrvgnd_1
XFILLER_63_39 VPWR VGND VPWR VGND sky130_ef_sc_hd__decap_12
XFILLER_82_397 VGND VGND VPWR VPWR sky130_fd_sc_hd__fill_1
XTAP_TAPCELL_ROW_25_437 VGND VPWR sky130_fd_sc_hd__tapvpwrvgnd_1
XFILLER_10_114 VPWR VGND VPWR VGND sky130_ef_sc_hd__decap_12
XFILLER_12_98 VGND VGND VPWR VPWR sky130_fd_sc_hd__fill_2
XFILLER_2_357 VGND VGND VPWR VPWR sky130_fd_sc_hd__decap_6
Xhold170 u_rx_fifo.mem\[6\]\[4\] VGND VGND VPWR VPWR net326 sky130_fd_sc_hd__dlygate4sd3_1
Xhold181 u_tx_fifo.mem\[11\]\[6\] VGND VGND VPWR VPWR net337 sky130_fd_sc_hd__dlygate4sd3_1
Xhold192 u_rx_fifo.mem\[10\]\[4\] VGND VGND VPWR VPWR net348 sky130_fd_sc_hd__dlygate4sd3_1
XFILLER_77_169 VGND VGND VPWR VPWR sky130_fd_sc_hd__decap_3
XFILLER_46_501 VGND VGND VPWR VPWR sky130_fd_sc_hd__fill_1
X_2440_ _1172_ VGND VGND VPWR VPWR _1173_ sky130_fd_sc_hd__inv_2
X_2371_ net439 net435 net18 VGND VGND VPWR VPWR _0297_ sky130_fd_sc_hd__mux2_1
XTAP_TAPCELL_ROW_67_838 VGND VPWR sky130_fd_sc_hd__tapvpwrvgnd_1
XFILLER_52_504 VGND VGND VPWR VPWR sky130_fd_sc_hd__fill_2
XTAP_TAPCELL_ROW_22_407 VGND VPWR sky130_fd_sc_hd__tapvpwrvgnd_1
XFILLER_20_401 VGND VGND VPWR VPWR sky130_fd_sc_hd__decap_4
X_3825_ clknet_leaf_7_clk _0641_ VGND VGND VPWR VPWR u_tx_fifo.mem\[0\]\[2\] sky130_fd_sc_hd__dfxtp_1
X_3756_ clknet_leaf_65_clk _0574_ VGND VGND VPWR VPWR u_tx_fifo.mem\[15\]\[5\] sky130_fd_sc_hd__dfxtp_1
XTAP_TAPCELL_ROW_30_484 VGND VPWR sky130_fd_sc_hd__tapvpwrvgnd_1
X_2707_ net41 u_parser.u_decoder.ascii_buf\[10\]\[0\] _1373_ VGND VGND VPWR VPWR _0400_
+ sky130_fd_sc_hd__mux2_1
X_3687_ clknet_leaf_58_clk _0514_ VGND VGND VPWR VPWR u_tx_fifo.mem\[1\]\[5\] sky130_fd_sc_hd__dfxtp_1
X_2638_ u_parser.u_decoder.ascii_buf\[0\]\[4\] u_parser.u_decoder.ascii_buf\[0\]\[5\]
+ VGND VGND VPWR VPWR _1325_ sky130_fd_sc_hd__nand2_1
X_2569_ u_parser.u_decoder.ascii_buf\[4\]\[0\] u_parser.u_decoder.ascii_buf\[4\]\[3\]
+ _1265_ _1271_ VGND VGND VPWR VPWR _1272_ sky130_fd_sc_hd__o31a_1
XFILLER_87_467 VGND VGND VPWR VPWR sky130_fd_sc_hd__fill_1
XFILLER_28_545 VGND VGND VPWR VPWR sky130_fd_sc_hd__decap_8
XFILLER_74_27 VGND VGND VPWR VPWR sky130_fd_sc_hd__fill_1
XTAP_TAPCELL_ROW_38_562 VGND VPWR sky130_fd_sc_hd__tapvpwrvgnd_1
XFILLER_90_15 VPWR VGND VPWR VGND sky130_ef_sc_hd__decap_12
XFILLER_11_445 VGND VGND VPWR VPWR sky130_fd_sc_hd__decap_3
XFILLER_7_405 VPWR VGND VPWR VGND sky130_ef_sc_hd__decap_12
XFILLER_7_449 VPWR VGND VPWR VGND sky130_ef_sc_hd__decap_12
XFILLER_48_83 VGND VGND VPWR VPWR sky130_fd_sc_hd__fill_1
XTAP_TAPCELL_ROW_64_808 VGND VPWR sky130_fd_sc_hd__tapvpwrvgnd_1
Xmax_cap5 _0966_ VGND VGND VPWR VPWR net5 sky130_fd_sc_hd__buf_2
XFILLER_65_139 VGND VGND VPWR VPWR sky130_fd_sc_hd__decap_6
XFILLER_61_378 VGND VGND VPWR VPWR sky130_fd_sc_hd__decap_3
X_1940_ net345 net80 _0943_ VGND VGND VPWR VPWR _0063_ sky130_fd_sc_hd__mux2_1
XFILLER_61_389 VGND VGND VPWR VPWR sky130_fd_sc_hd__decap_3
XTAP_TAPCELL_ROW_72_885 VGND VPWR sky130_fd_sc_hd__tapvpwrvgnd_1
XFILLER_9_66 VGND VGND VPWR VPWR sky130_fd_sc_hd__fill_1
X_1871_ u_parser.u_packet_encoder.tag_latched\[16\] _0899_ _0900_ u_parser.u_packet_encoder.tag_latched\[24\]
+ _0897_ VGND VGND VPWR VPWR _0901_ sky130_fd_sc_hd__a221o_1
X_3610_ clknet_leaf_38_clk _0437_ net128 VGND VGND VPWR VPWR u_parser.u_decoder.decoded_checksum_rx\[5\]
+ sky130_fd_sc_hd__dfrtp_1
X_3541_ clknet_leaf_43_clk _0368_ net111 VGND VGND VPWR VPWR u_parser.u_decoder.decoded_payload\[24\]
+ sky130_fd_sc_hd__dfrtp_1
X_3472_ clknet_leaf_45_clk _0299_ net110 VGND VGND VPWR VPWR tag_raw\[26\] sky130_fd_sc_hd__dfrtp_1
XFILLER_50_3 VPWR VGND VPWR VGND sky130_ef_sc_hd__decap_12
X_2423_ net615 _1159_ _1161_ VGND VGND VPWR VPWR _0328_ sky130_fd_sc_hd__a21oi_1
X_2354_ tag_raw\[7\] net419 net16 VGND VGND VPWR VPWR _0280_ sky130_fd_sc_hd__mux2_1
X_2285_ u_tx_fifo.mem\[0\]\[3\] u_tx_fifo.mem\[1\]\[3\] u_tx_fifo.mem\[2\]\[3\] u_tx_fifo.mem\[3\]\[3\]
+ net69 net65 VGND VGND VPWR VPWR _1092_ sky130_fd_sc_hd__mux4_1
XFILLER_56_139 VGND VGND VPWR VPWR sky130_fd_sc_hd__fill_1
XFILLER_25_537 VPWR VGND VPWR VGND sky130_ef_sc_hd__decap_12
XTAP_TAPCELL_ROW_35_532 VGND VPWR sky130_fd_sc_hd__tapvpwrvgnd_1
XFILLER_52_356 VGND VGND VPWR VPWR sky130_fd_sc_hd__decap_8
XFILLER_20_220 VGND VGND VPWR VPWR sky130_fd_sc_hd__fill_1
X_3808_ clknet_leaf_60_clk _0625_ net88 VGND VGND VPWR VPWR u_tx_fifo.rd_ptr\[0\]
+ sky130_fd_sc_hd__dfrtp_2
XFILLER_20_253 VGND VGND VPWR VPWR sky130_fd_sc_hd__decap_6
XFILLER_60_29 VPWR VGND VPWR VGND sky130_ef_sc_hd__decap_12
X_3739_ clknet_leaf_64_clk _0563_ VGND VGND VPWR VPWR u_tx_fifo.mem\[8\]\[2\] sky130_fd_sc_hd__dfxtp_1
XFILLER_4_419 VGND VGND VPWR VPWR sky130_fd_sc_hd__fill_1
XFILLER_69_27 VPWR VGND VPWR VGND sky130_ef_sc_hd__decap_12
XFILLER_85_15 VPWR VGND VPWR VGND sky130_ef_sc_hd__decap_12
XTAP_TAPCELL_ROW_7_268 VGND VPWR sky130_fd_sc_hd__tapvpwrvgnd_1
XFILLER_75_459 VPWR VGND VPWR VGND sky130_ef_sc_hd__decap_12
XFILLER_43_367 VGND VGND VPWR VPWR sky130_fd_sc_hd__decap_4
XFILLER_43_389 VGND VGND VPWR VPWR sky130_fd_sc_hd__decap_3
XFILLER_11_242 VPWR VGND VPWR VGND sky130_ef_sc_hd__decap_12
XFILLER_7_246 VPWR VGND VPWR VGND sky130_ef_sc_hd__decap_12
XFILLER_3_441 VGND VGND VPWR VPWR sky130_fd_sc_hd__decap_6
XFILLER_3_485 VPWR VGND VPWR VGND sky130_ef_sc_hd__decap_12
XFILLER_78_253 VGND VGND VPWR VPWR sky130_fd_sc_hd__fill_1
XTAP_TAPCELL_ROW_77_933 VGND VPWR sky130_fd_sc_hd__tapvpwrvgnd_1
X_2070_ net26 net301 _0962_ VGND VGND VPWR VPWR _0174_ sky130_fd_sc_hd__mux2_1
XTAP_TAPCELL_ROW_49_668 VGND VPWR sky130_fd_sc_hd__tapvpwrvgnd_1
XFILLER_46_194 VGND VGND VPWR VPWR sky130_fd_sc_hd__fill_2
X_2972_ u_uart_rx.low_count\[0\] _0838_ _1491_ VGND VGND VPWR VPWR _1492_ sky130_fd_sc_hd__and3_1
XTAP_TAPCELL_ROW_32_502 VGND VPWR sky130_fd_sc_hd__tapvpwrvgnd_1
XFILLER_61_186 VGND VGND VPWR VPWR sky130_fd_sc_hd__decap_6
X_1923_ net400 net79 _0941_ VGND VGND VPWR VPWR _0048_ sky130_fd_sc_hd__mux2_1
X_1854_ net196 net78 _0888_ VGND VGND VPWR VPWR _0032_ sky130_fd_sc_hd__mux2_1
X_1785_ net87 _0844_ VGND VGND VPWR VPWR _0009_ sky130_fd_sc_hd__nor2_1
X_3524_ clknet_leaf_57_clk _0351_ net95 VGND VGND VPWR VPWR u_parser.u_decoder.decoded_payload\[7\]
+ sky130_fd_sc_hd__dfrtp_1
Xfanout7 net9 VGND VGND VPWR VPWR net7 sky130_fd_sc_hd__clkbuf_4
XFILLER_89_529 VPWR VGND VPWR VGND sky130_ef_sc_hd__decap_12
X_3455_ clknet_leaf_46_clk _0282_ net104 VGND VGND VPWR VPWR tag_raw\[9\] sky130_fd_sc_hd__dfrtp_1
X_2406_ u_parser.u_decoder.index\[2\] _1146_ _1149_ VGND VGND VPWR VPWR _0323_ sky130_fd_sc_hd__a21bo_1
X_3386_ clknet_leaf_56_clk _0219_ net97 VGND VGND VPWR VPWR u_parser.u_packet_encoder.tag_latched\[22\]
+ sky130_fd_sc_hd__dfrtp_1
X_2337_ net73 net409 _1132_ VGND VGND VPWR VPWR _0271_ sky130_fd_sc_hd__mux2_1
XTAP_TAPCELL_ROW_4_238 VGND VPWR sky130_fd_sc_hd__tapvpwrvgnd_1
XFILLER_57_415 VGND VGND VPWR VPWR sky130_fd_sc_hd__decap_4
XFILLER_69_264 VGND VGND VPWR VPWR sky130_fd_sc_hd__fill_1
X_2268_ u_tx_fifo.mem\[4\]\[1\] u_tx_fifo.mem\[5\]\[1\] u_tx_fifo.mem\[6\]\[1\] u_tx_fifo.mem\[7\]\[1\]
+ net68 net64 VGND VGND VPWR VPWR _1077_ sky130_fd_sc_hd__mux4_1
XFILLER_72_418 VGND VGND VPWR VPWR sky130_fd_sc_hd__fill_2
XFILLER_72_429 VGND VGND VPWR VPWR sky130_fd_sc_hd__decap_4
X_2199_ tag_raw\[6\] net510 net53 VGND VGND VPWR VPWR _0203_ sky130_fd_sc_hd__mux2_1
XFILLER_25_367 VPWR VGND VPWR VGND sky130_ef_sc_hd__decap_12
XFILLER_52_153 VGND VGND VPWR VPWR sky130_fd_sc_hd__decap_6
XFILLER_13_529 VPWR VGND VPWR VGND sky130_ef_sc_hd__decap_12
XFILLER_52_197 VPWR VGND VPWR VGND sky130_ef_sc_hd__decap_12
XFILLER_71_39 VGND VGND VPWR VPWR sky130_fd_sc_hd__decap_6
XFILLER_0_433 VPWR VGND VPWR VGND sky130_ef_sc_hd__decap_12
Xhold30 u_tx_fifo.mem\[8\]\[0\] VGND VGND VPWR VPWR net186 sky130_fd_sc_hd__dlygate4sd3_1
XFILLER_0_477 VPWR VGND VPWR VGND sky130_ef_sc_hd__decap_12
XFILLER_29_41 VGND VGND VPWR VPWR sky130_fd_sc_hd__decap_6
Xhold41 u_tx_fifo.mem\[4\]\[2\] VGND VGND VPWR VPWR net197 sky130_fd_sc_hd__dlygate4sd3_1
Xhold63 u_rx_fifo.mem\[6\]\[1\] VGND VGND VPWR VPWR net219 sky130_fd_sc_hd__dlygate4sd3_1
Xhold74 u_tx_fifo.mem\[6\]\[6\] VGND VGND VPWR VPWR net230 sky130_fd_sc_hd__dlygate4sd3_1
Xhold52 u_tx_fifo.mem\[4\]\[1\] VGND VGND VPWR VPWR net208 sky130_fd_sc_hd__dlygate4sd3_1
Xhold85 u_rx_fifo.mem\[0\]\[4\] VGND VGND VPWR VPWR net241 sky130_fd_sc_hd__dlygate4sd3_1
Xhold96 u_rx_fifo.mem\[14\]\[6\] VGND VGND VPWR VPWR net252 sky130_fd_sc_hd__dlygate4sd3_1
XTAP_TAPCELL_ROW_74_903 VGND VPWR sky130_fd_sc_hd__tapvpwrvgnd_1
XFILLER_75_256 VGND VGND VPWR VPWR sky130_fd_sc_hd__fill_2
XFILLER_90_237 VGND VGND VPWR VPWR sky130_fd_sc_hd__decap_6
XTAP_TAPCELL_ROW_46_638 VGND VPWR sky130_fd_sc_hd__tapvpwrvgnd_1
XFILLER_43_142 VGND VGND VPWR VPWR sky130_fd_sc_hd__fill_2
XFILLER_45_51 VGND VGND VPWR VPWR sky130_fd_sc_hd__decap_4
XTAP_TAPCELL_ROW_82_980 VGND VPWR sky130_fd_sc_hd__tapvpwrvgnd_1
XFILLER_16_389 VGND VGND VPWR VPWR sky130_fd_sc_hd__fill_2
XFILLER_43_186 VGND VGND VPWR VPWR sky130_fd_sc_hd__fill_2
XFILLER_61_61 VGND VGND VPWR VPWR sky130_fd_sc_hd__fill_1
XFILLER_8_533 VPWR VGND VPWR VGND sky130_ef_sc_hd__decap_12
XFILLER_6_45 VGND VGND VPWR VPWR sky130_fd_sc_hd__fill_1
X_3240_ clknet_leaf_17_clk _0076_ VGND VGND VPWR VPWR u_rx_fifo.mem\[5\]\[7\] sky130_fd_sc_hd__dfxtp_1
X_3171_ net31 net254 _1586_ VGND VGND VPWR VPWR _0651_ sky130_fd_sc_hd__mux2_1
XFILLER_13_3 VGND VGND VPWR VPWR sky130_fd_sc_hd__fill_1
X_2122_ tag_raw\[22\] _0999_ VGND VGND VPWR VPWR _1000_ sky130_fd_sc_hd__xor2_1
XFILLER_66_245 VGND VGND VPWR VPWR sky130_fd_sc_hd__decap_6
XTAP_TAPCELL_ROW_1_208 VGND VPWR sky130_fd_sc_hd__tapvpwrvgnd_1
XFILLER_54_418 VGND VGND VPWR VPWR sky130_fd_sc_hd__fill_2
X_2053_ net273 net79 _0959_ VGND VGND VPWR VPWR _0160_ sky130_fd_sc_hd__mux2_1
XFILLER_62_440 VGND VGND VPWR VPWR sky130_fd_sc_hd__fill_1
XTAP_TAPCELL_ROW_17_362 VGND VPWR sky130_fd_sc_hd__tapvpwrvgnd_1
XFILLER_34_164 VGND VGND VPWR VPWR sky130_fd_sc_hd__decap_3
XFILLER_22_359 VGND VGND VPWR VPWR sky130_fd_sc_hd__decap_4
XFILLER_34_197 VGND VGND VPWR VPWR sky130_fd_sc_hd__fill_1
X_2955_ u_uart_rx.low_count\[7\] _1480_ net86 VGND VGND VPWR VPWR _1481_ sky130_fd_sc_hd__a21oi_1
X_1906_ u_parser.u_packet_encoder.tag_latched\[21\] _0899_ _0902_ u_parser.u_packet_encoder.tag_latched\[5\]
+ _0929_ VGND VGND VPWR VPWR _0931_ sky130_fd_sc_hd__a221o_1
X_2886_ net22 net394 _1438_ VGND VGND VPWR VPWR _0514_ sky130_fd_sc_hd__mux2_1
X_1837_ net645 card_event _0879_ _0882_ VGND VGND VPWR VPWR _0020_ sky130_fd_sc_hd__o22a_1
X_3507_ clknet_leaf_29_clk _0334_ net137 VGND VGND VPWR VPWR u_parser.u_decoder.timeout_count\[9\]
+ sky130_fd_sc_hd__dfrtp_1
X_1768_ _0661_ u_uart_tx.state\[0\] _0825_ VGND VGND VPWR VPWR _0831_ sky130_fd_sc_hd__and3_1
XFILLER_89_337 VGND VGND VPWR VPWR sky130_fd_sc_hd__decap_6
X_1699_ u_rx_fifo.mem\[4\]\[2\] u_rx_fifo.mem\[5\]\[2\] u_rx_fifo.mem\[6\]\[2\] u_rx_fifo.mem\[7\]\[2\]
+ net151 net147 VGND VGND VPWR VPWR _0766_ sky130_fd_sc_hd__mux4_1
X_3438_ clknet_leaf_17_clk _0271_ VGND VGND VPWR VPWR u_rx_fifo.mem\[1\]\[6\] sky130_fd_sc_hd__dfxtp_1
X_3369_ clknet_leaf_52_clk _0202_ net94 VGND VGND VPWR VPWR u_parser.u_packet_encoder.tag_latched\[5\]
+ sky130_fd_sc_hd__dfrtp_1
XFILLER_17_109 VGND VGND VPWR VPWR sky130_fd_sc_hd__decap_3
XFILLER_57_289 VGND VGND VPWR VPWR sky130_fd_sc_hd__fill_1
XFILLER_82_27 VGND VGND VPWR VPWR sky130_fd_sc_hd__fill_1
XTAP_TAPCELL_ROW_43_608 VGND VPWR sky130_fd_sc_hd__tapvpwrvgnd_1
XFILLER_15_65 VGND VGND VPWR VPWR sky130_fd_sc_hd__fill_2
XFILLER_15_54 VGND VGND VPWR VPWR sky130_fd_sc_hd__fill_2
XFILLER_13_348 VGND VGND VPWR VPWR sky130_fd_sc_hd__decap_6
XFILLER_21_381 VGND VGND VPWR VPWR sky130_fd_sc_hd__decap_8
XTAP_TAPCELL_ROW_51_685 VGND VPWR sky130_fd_sc_hd__tapvpwrvgnd_1
XFILLER_5_503 VGND VGND VPWR VPWR sky130_fd_sc_hd__fill_1
XFILLER_31_97 VGND VGND VPWR VPWR sky130_fd_sc_hd__decap_6
XTAP_TAPCELL_ROW_91_1069 VGND VPWR sky130_fd_sc_hd__tapvpwrvgnd_1
XFILLER_0_285 VPWR VGND VPWR VGND sky130_ef_sc_hd__decap_12
XFILLER_48_278 VGND VGND VPWR VPWR sky130_fd_sc_hd__decap_3
XTAP_TAPCELL_ROW_59_763 VGND VPWR sky130_fd_sc_hd__tapvpwrvgnd_1
XFILLER_71_281 VGND VGND VPWR VPWR sky130_fd_sc_hd__decap_4
XTAP_TAPCELL_ROW_14_332 VGND VPWR sky130_fd_sc_hd__tapvpwrvgnd_1
XFILLER_72_93 VGND VGND VPWR VPWR sky130_fd_sc_hd__decap_3
XFILLER_31_178 VGND VGND VPWR VPWR sky130_fd_sc_hd__fill_1
X_2740_ net42 net641 _1376_ VGND VGND VPWR VPWR _0430_ sky130_fd_sc_hd__mux2_1
XFILLER_8_363 VGND VGND VPWR VPWR sky130_fd_sc_hd__fill_1
X_2671_ _1236_ _1293_ VGND VGND VPWR VPWR _1351_ sky130_fd_sc_hd__xnor2_1
X_1622_ u_uart_rx.sample_div_count\[0\] u_uart_rx.sample_div_count\[2\] _0690_ _0691_
+ VGND VGND VPWR VPWR _0692_ sky130_fd_sc_hd__or4_1
X_3223_ clknet_leaf_15_clk _0059_ VGND VGND VPWR VPWR u_rx_fifo.mem\[7\]\[6\] sky130_fd_sc_hd__dfxtp_1
X_3154_ _0705_ _1572_ _1578_ u_uart_rx.rx_shift\[6\] VGND VGND VPWR VPWR _1584_ sky130_fd_sc_hd__o31a_1
XFILLER_67_554 VGND VGND VPWR VPWR sky130_fd_sc_hd__fill_1
X_3085_ _1525_ _1543_ VGND VGND VPWR VPWR _1544_ sky130_fd_sc_hd__nor2_1
X_2105_ _0975_ _0982_ VGND VGND VPWR VPWR _0983_ sky130_fd_sc_hd__xnor2_4
X_2036_ net31 net288 _0957_ VGND VGND VPWR VPWR _0145_ sky130_fd_sc_hd__mux2_1
XFILLER_35_495 VGND VGND VPWR VPWR sky130_fd_sc_hd__decap_8
XFILLER_50_421 VPWR VGND VPWR VGND sky130_ef_sc_hd__decap_12
X_2938_ net647 _0844_ _1470_ VGND VGND VPWR VPWR _0534_ sky130_fd_sc_hd__o21a_1
X_2869_ net20 net309 _1436_ VGND VGND VPWR VPWR _0499_ sky130_fd_sc_hd__mux2_1
XFILLER_89_101 VGND VGND VPWR VPWR sky130_fd_sc_hd__fill_2
Xhold341 u_uart_tx.tx_data\[3\] VGND VGND VPWR VPWR net497 sky130_fd_sc_hd__dlygate4sd3_1
Xhold352 u_parser.u_packet_encoder.tag_latched\[8\] VGND VGND VPWR VPWR net508 sky130_fd_sc_hd__dlygate4sd3_1
Xhold330 u_parser.u_decoder.decoded_payload\[31\] VGND VGND VPWR VPWR net486 sky130_fd_sc_hd__dlygate4sd3_1
XFILLER_77_27 VPWR VGND VPWR VGND sky130_ef_sc_hd__decap_12
Xhold363 _0215_ VGND VGND VPWR VPWR net519 sky130_fd_sc_hd__dlygate4sd3_1
Xhold385 u_parser.u_packet_encoder.tag_latched\[31\] VGND VGND VPWR VPWR net541 sky130_fd_sc_hd__dlygate4sd3_1
Xhold396 u_parser.u_packet_encoder.tag_latched\[22\] VGND VGND VPWR VPWR net552 sky130_fd_sc_hd__dlygate4sd3_1
Xhold374 u_parser.u_packet_encoder.tag_latched\[29\] VGND VGND VPWR VPWR net530 sky130_fd_sc_hd__dlygate4sd3_1
XFILLER_89_167 VGND VGND VPWR VPWR sky130_fd_sc_hd__fill_1
XFILLER_93_15 VPWR VGND VPWR VGND sky130_ef_sc_hd__decap_12
XTAP_TAPCELL_ROW_56_733 VGND VPWR sky130_fd_sc_hd__tapvpwrvgnd_1
XTAP_TAPCELL_ROW_28_468 VGND VPWR sky130_fd_sc_hd__tapvpwrvgnd_1
Xclkbuf_3_6__f_clk clknet_0_clk VGND VGND VPWR VPWR clknet_3_6__leaf_clk sky130_fd_sc_hd__clkbuf_16
XFILLER_53_281 VPWR VGND VPWR VGND sky130_ef_sc_hd__decap_12
XFILLER_13_167 VGND VGND VPWR VPWR sky130_fd_sc_hd__fill_1
XFILLER_41_443 VGND VGND VPWR VPWR sky130_fd_sc_hd__decap_4
XFILLER_13_189 VGND VGND VPWR VPWR sky130_fd_sc_hd__decap_4
XTAP_TAPCELL_ROW_11_302 VGND VPWR sky130_fd_sc_hd__tapvpwrvgnd_1
XFILLER_9_149 VGND VGND VPWR VPWR sky130_fd_sc_hd__decap_3
XFILLER_42_41 VPWR VGND VPWR VGND sky130_ef_sc_hd__decap_12
XFILLER_42_85 VPWR VGND VPWR VGND sky130_ef_sc_hd__decap_12
XFILLER_5_300 VGND VGND VPWR VPWR sky130_fd_sc_hd__decap_8
XPHY_EDGE_ROW_39_Left_133 VGND VGND VPWR VPWR sky130_fd_sc_hd__decap_3
XFILLER_76_395 VGND VGND VPWR VPWR sky130_fd_sc_hd__fill_2
XPHY_EDGE_ROW_48_Left_142 VGND VGND VPWR VPWR sky130_fd_sc_hd__decap_3
X_3772_ clknet_leaf_16_clk _0590_ VGND VGND VPWR VPWR u_rx_fifo.mem\[2\]\[5\] sky130_fd_sc_hd__dfxtp_1
XFILLER_80_3 VPWR VGND VPWR VGND sky130_ef_sc_hd__decap_12
X_2723_ _0964_ _1142_ net425 VGND VGND VPWR VPWR _0415_ sky130_fd_sc_hd__o21a_1
XFILLER_8_171 VGND VGND VPWR VPWR sky130_fd_sc_hd__fill_2
XPHY_EDGE_ROW_57_Left_151 VGND VGND VPWR VPWR sky130_fd_sc_hd__decap_3
XFILLER_8_182 VGND VGND VPWR VPWR sky130_fd_sc_hd__decap_4
X_2654_ u_parser.u_decoder.ascii_buf\[0\]\[3\] net45 _1331_ VGND VGND VPWR VPWR _1338_
+ sky130_fd_sc_hd__a21o_1
X_2585_ u_parser.u_decoder.ascii_buf\[3\]\[0\] u_parser.u_decoder.ascii_buf\[3\]\[1\]
+ u_parser.u_decoder.ascii_buf\[3\]\[2\] _1283_ VGND VGND VPWR VPWR _1284_ sky130_fd_sc_hd__a31oi_1
X_1605_ u_parser.u_decoder.decoded_checksum_rx\[1\] VGND VGND VPWR VPWR _0675_ sky130_fd_sc_hd__inv_2
Xfanout106 net107 VGND VGND VPWR VPWR net106 sky130_fd_sc_hd__clkbuf_4
Xfanout117 net119 VGND VGND VPWR VPWR net117 sky130_fd_sc_hd__clkbuf_4
Xfanout128 net130 VGND VGND VPWR VPWR net128 sky130_fd_sc_hd__clkbuf_4
Xfanout139 net144 VGND VGND VPWR VPWR net139 sky130_fd_sc_hd__clkbuf_2
X_3206_ clknet_leaf_2_clk _0042_ VGND VGND VPWR VPWR u_tx_fifo.mem\[7\]\[5\] sky130_fd_sc_hd__dfxtp_1
XPHY_EDGE_ROW_66_Left_160 VGND VGND VPWR VPWR sky130_fd_sc_hd__decap_3
X_3137_ u_uart_rx.bit_index\[2\] _1555_ VGND VGND VPWR VPWR _1572_ sky130_fd_sc_hd__xnor2_1
X_3068_ u_uart_rx.sample_div_count\[1\] u_uart_rx.sample_div_count\[0\] _1510_ _1529_
+ VGND VGND VPWR VPWR _1532_ sky130_fd_sc_hd__and4_1
XFILLER_82_365 VPWR VGND VPWR VGND sky130_ef_sc_hd__decap_12
XTAP_TAPCELL_ROW_53_703 VGND VPWR sky130_fd_sc_hd__tapvpwrvgnd_1
XTAP_TAPCELL_ROW_25_438 VGND VPWR sky130_fd_sc_hd__tapvpwrvgnd_1
X_2019_ net21 net308 _0955_ VGND VGND VPWR VPWR _0130_ sky130_fd_sc_hd__mux2_1
XFILLER_42_229 VGND VGND VPWR VPWR sky130_fd_sc_hd__fill_1
XTAP_TAPCELL_ROW_61_780 VGND VPWR sky130_fd_sc_hd__tapvpwrvgnd_1
XFILLER_12_11 VGND VGND VPWR VPWR sky130_fd_sc_hd__fill_1
XFILLER_10_126 VGND VGND VPWR VPWR sky130_fd_sc_hd__fill_2
XFILLER_88_15 VPWR VGND VPWR VGND sky130_ef_sc_hd__decap_12
Xhold171 u_tx_fifo.mem\[9\]\[4\] VGND VGND VPWR VPWR net327 sky130_fd_sc_hd__dlygate4sd3_1
Xhold160 u_tx_fifo.mem\[6\]\[7\] VGND VGND VPWR VPWR net316 sky130_fd_sc_hd__dlygate4sd3_1
Xhold182 u_tx_fifo.mem\[7\]\[4\] VGND VGND VPWR VPWR net338 sky130_fd_sc_hd__dlygate4sd3_1
Xhold193 u_rx_fifo.mem\[11\]\[0\] VGND VGND VPWR VPWR net349 sky130_fd_sc_hd__dlygate4sd3_1
XFILLER_18_248 VGND VGND VPWR VPWR sky130_fd_sc_hd__decap_4
XFILLER_73_365 VGND VGND VPWR VPWR sky130_fd_sc_hd__decap_4
XFILLER_14_421 VGND VGND VPWR VPWR sky130_fd_sc_hd__decap_6
XFILLER_61_538 VPWR VGND VPWR VGND sky130_ef_sc_hd__decap_12
XFILLER_53_51 VGND VGND VPWR VPWR sky130_fd_sc_hd__decap_4
XFILLER_5_163 VGND VGND VPWR VPWR sky130_fd_sc_hd__fill_1
X_2370_ tag_raw\[23\] net427 net15 VGND VGND VPWR VPWR _0296_ sky130_fd_sc_hd__mux2_1
XFILLER_68_115 VGND VGND VPWR VPWR sky130_fd_sc_hd__fill_2
XFILLER_37_502 VGND VGND VPWR VPWR sky130_fd_sc_hd__fill_2
XTAP_TAPCELL_ROW_67_839 VGND VPWR sky130_fd_sc_hd__tapvpwrvgnd_1
XFILLER_76_192 VGND VGND VPWR VPWR sky130_fd_sc_hd__decap_4
XFILLER_24_218 VGND VGND VPWR VPWR sky130_fd_sc_hd__decap_6
XFILLER_64_354 VGND VGND VPWR VPWR sky130_fd_sc_hd__fill_1
XFILLER_64_365 VPWR VGND VPWR VGND sky130_ef_sc_hd__decap_12
XTAP_TAPCELL_ROW_22_408 VGND VPWR sky130_fd_sc_hd__tapvpwrvgnd_1
XFILLER_32_295 VPWR VGND VPWR VGND sky130_ef_sc_hd__decap_12
X_3824_ clknet_leaf_7_clk _0640_ VGND VGND VPWR VPWR u_tx_fifo.mem\[0\]\[1\] sky130_fd_sc_hd__dfxtp_1
X_3755_ clknet_leaf_65_clk _0573_ VGND VGND VPWR VPWR u_tx_fifo.mem\[15\]\[4\] sky130_fd_sc_hd__dfxtp_1
X_3686_ clknet_leaf_58_clk _0513_ VGND VGND VPWR VPWR u_tx_fifo.mem\[1\]\[4\] sky130_fd_sc_hd__dfxtp_1
XTAP_TAPCELL_ROW_30_485 VGND VPWR sky130_fd_sc_hd__tapvpwrvgnd_1
X_2706_ u_parser.u_decoder.index\[0\] u_parser.u_decoder.index\[1\] net5 VGND VGND
+ VPWR VPWR _1373_ sky130_fd_sc_hd__nand3b_4
XPHY_EDGE_ROW_12_Right_12 VGND VGND VPWR VPWR sky130_fd_sc_hd__decap_3
X_2637_ u_parser.u_decoder.ascii_buf\[0\]\[1\] u_parser.u_decoder.ascii_buf\[0\]\[2\]
+ VGND VGND VPWR VPWR _1324_ sky130_fd_sc_hd__or2_1
X_2568_ u_parser.u_decoder.ascii_buf\[4\]\[0\] u_parser.u_decoder.ascii_buf\[4\]\[1\]
+ u_parser.u_decoder.ascii_buf\[4\]\[2\] _1270_ VGND VGND VPWR VPWR _1271_ sky130_fd_sc_hd__a31oi_1
XFILLER_58_29 VPWR VGND VPWR VGND sky130_ef_sc_hd__decap_12
XFILLER_87_446 VGND VGND VPWR VPWR sky130_fd_sc_hd__fill_2
X_2499_ u_parser.u_decoder.ascii_buf\[8\]\[1\] _1211_ VGND VGND VPWR VPWR _1217_ sky130_fd_sc_hd__xnor2_1
XPHY_EDGE_ROW_21_Right_21 VGND VGND VPWR VPWR sky130_fd_sc_hd__decap_3
XTAP_TAPCELL_ROW_38_563 VGND VPWR sky130_fd_sc_hd__tapvpwrvgnd_1
XFILLER_15_229 VGND VGND VPWR VPWR sky130_fd_sc_hd__fill_2
XFILLER_90_27 VGND VGND VPWR VPWR sky130_fd_sc_hd__fill_1
XFILLER_23_262 VPWR VGND VPWR VGND sky130_ef_sc_hd__decap_12
XFILLER_7_417 VPWR VGND VPWR VGND sky130_ef_sc_hd__decap_12
XPHY_EDGE_ROW_30_Right_30 VGND VGND VPWR VPWR sky130_fd_sc_hd__decap_3
XFILLER_93_405 VPWR VGND VPWR VGND sky130_ef_sc_hd__decap_12
XFILLER_93_449 VPWR VGND VPWR VGND sky130_ef_sc_hd__decap_12
XFILLER_46_321 VGND VGND VPWR VPWR sky130_fd_sc_hd__decap_4
XTAP_TAPCELL_ROW_64_809 VGND VPWR sky130_fd_sc_hd__tapvpwrvgnd_1
XFILLER_61_313 VGND VGND VPWR VPWR sky130_fd_sc_hd__fill_1
XFILLER_61_335 VGND VGND VPWR VPWR sky130_fd_sc_hd__fill_1
XFILLER_64_83 VGND VGND VPWR VPWR sky130_fd_sc_hd__fill_1
XTAP_TAPCELL_ROW_72_886 VGND VPWR sky130_fd_sc_hd__tapvpwrvgnd_1
X_1870_ _0878_ _0893_ VGND VGND VPWR VPWR _0900_ sky130_fd_sc_hd__nor2_4
XFILLER_80_93 VGND VGND VPWR VPWR sky130_fd_sc_hd__decap_6
X_3540_ clknet_leaf_39_clk _0367_ net100 VGND VGND VPWR VPWR u_parser.u_decoder.decoded_payload\[23\]
+ sky130_fd_sc_hd__dfrtp_1
X_3471_ clknet_leaf_45_clk _0298_ net110 VGND VGND VPWR VPWR tag_raw\[25\] sky130_fd_sc_hd__dfrtp_1
X_2422_ u_parser.u_decoder.timeout_count\[3\] _1159_ net3 VGND VGND VPWR VPWR _1161_
+ sky130_fd_sc_hd__o21ai_1
XFILLER_43_3 VPWR VGND VPWR VGND sky130_ef_sc_hd__decap_12
X_2353_ tag_raw\[6\] net489 net16 VGND VGND VPWR VPWR _0279_ sky130_fd_sc_hd__mux2_1
X_2284_ net462 _1091_ net49 VGND VGND VPWR VPWR _0259_ sky130_fd_sc_hd__mux2_1
XFILLER_92_471 VGND VGND VPWR VPWR sky130_fd_sc_hd__decap_4
XFILLER_25_549 VGND VGND VPWR VPWR sky130_fd_sc_hd__decap_6
XTAP_TAPCELL_ROW_35_533 VGND VPWR sky130_fd_sc_hd__tapvpwrvgnd_1
X_3807_ clknet_leaf_32_clk _0009_ net142 VGND VGND VPWR VPWR u_uart_rx.break_detect
+ sky130_fd_sc_hd__dfrtp_4
X_1999_ net164 net31 _0952_ VGND VGND VPWR VPWR _0113_ sky130_fd_sc_hd__mux2_1
XFILLER_20_298 VGND VGND VPWR VPWR sky130_fd_sc_hd__decap_8
X_3738_ clknet_leaf_62_clk _0562_ VGND VGND VPWR VPWR u_tx_fifo.mem\[8\]\[1\] sky130_fd_sc_hd__dfxtp_1
X_3669_ clknet_leaf_61_clk _0496_ VGND VGND VPWR VPWR u_tx_fifo.mem\[9\]\[3\] sky130_fd_sc_hd__dfxtp_1
XFILLER_69_39 VPWR VGND VPWR VGND sky130_ef_sc_hd__decap_12
XTAP_TAPCELL_ROW_7_269 VGND VPWR sky130_fd_sc_hd__tapvpwrvgnd_1
XFILLER_85_27 VGND VGND VPWR VPWR sky130_fd_sc_hd__decap_4
XFILLER_75_416 VGND VGND VPWR VPWR sky130_fd_sc_hd__decap_4
XFILLER_90_419 VGND VGND VPWR VPWR sky130_fd_sc_hd__fill_1
XTAP_TAPCELL_ROW_87_1030 VGND VPWR sky130_fd_sc_hd__tapvpwrvgnd_1
XFILLER_11_254 VGND VGND VPWR VPWR sky130_fd_sc_hd__decap_4
XFILLER_7_225 VGND VGND VPWR VPWR sky130_fd_sc_hd__decap_4
XFILLER_50_41 VPWR VGND VPWR VGND sky130_ef_sc_hd__decap_12
XFILLER_7_258 VGND VGND VPWR VPWR sky130_fd_sc_hd__fill_2
XFILLER_50_85 VPWR VGND VPWR VGND sky130_ef_sc_hd__decap_12
XFILLER_3_497 VGND VGND VPWR VPWR sky130_fd_sc_hd__decap_6
XFILLER_59_72 VPWR VGND VPWR VGND sky130_ef_sc_hd__decap_12
XFILLER_66_416 VGND VGND VPWR VPWR sky130_fd_sc_hd__decap_4
XTAP_TAPCELL_ROW_77_934 VGND VPWR sky130_fd_sc_hd__tapvpwrvgnd_1
Xclkbuf_leaf_58_clk clknet_3_0__leaf_clk VGND VGND VPWR VPWR clknet_leaf_58_clk sky130_fd_sc_hd__clkbuf_8
XFILLER_59_490 VGND VGND VPWR VPWR sky130_fd_sc_hd__decap_6
XTAP_TAPCELL_ROW_49_669 VGND VPWR sky130_fd_sc_hd__tapvpwrvgnd_1
XFILLER_34_357 VGND VGND VPWR VPWR sky130_fd_sc_hd__decap_6
X_2971_ u_uart_rx.low_count\[6\] u_uart_rx.low_count\[5\] _1490_ VGND VGND VPWR VPWR
+ _1491_ sky130_fd_sc_hd__and3_1
XTAP_TAPCELL_ROW_32_503 VGND VPWR sky130_fd_sc_hd__tapvpwrvgnd_1
X_1922_ net165 net81 _0941_ VGND VGND VPWR VPWR _0047_ sky130_fd_sc_hd__mux2_1
X_1853_ net192 net80 _0888_ VGND VGND VPWR VPWR _0031_ sky130_fd_sc_hd__mux2_1
XTAP_TAPCELL_ROW_40_580 VGND VPWR sky130_fd_sc_hd__tapvpwrvgnd_1
X_1784_ _0841_ _0842_ _0843_ VGND VGND VPWR VPWR _0844_ sky130_fd_sc_hd__nor3_2
X_3523_ clknet_leaf_57_clk _0350_ net95 VGND VGND VPWR VPWR u_parser.u_decoder.decoded_payload\[6\]
+ sky130_fd_sc_hd__dfrtp_1
Xfanout8 net9 VGND VGND VPWR VPWR net8 sky130_fd_sc_hd__clkbuf_4
X_3454_ clknet_leaf_45_clk _0281_ net110 VGND VGND VPWR VPWR tag_raw\[8\] sky130_fd_sc_hd__dfrtp_1
X_2405_ _0710_ _0782_ _1146_ _1148_ VGND VGND VPWR VPWR _1149_ sky130_fd_sc_hd__or4_1
X_3385_ clknet_leaf_54_clk _0218_ net98 VGND VGND VPWR VPWR u_parser.u_packet_encoder.tag_latched\[21\]
+ sky130_fd_sc_hd__dfrtp_1
XFILLER_69_221 VGND VGND VPWR VPWR sky130_fd_sc_hd__decap_3
X_2336_ net75 net364 _1132_ VGND VGND VPWR VPWR _0270_ sky130_fd_sc_hd__mux2_1
XTAP_TAPCELL_ROW_4_239 VGND VPWR sky130_fd_sc_hd__tapvpwrvgnd_1
Xclkbuf_leaf_49_clk clknet_3_2__leaf_clk VGND VGND VPWR VPWR clknet_leaf_49_clk sky130_fd_sc_hd__clkbuf_8
X_2267_ u_tx_fifo.mem\[0\]\[1\] u_tx_fifo.mem\[1\]\[1\] u_tx_fifo.mem\[2\]\[1\] u_tx_fifo.mem\[3\]\[1\]
+ net69 net65 VGND VGND VPWR VPWR _1076_ sky130_fd_sc_hd__mux4_1
XFILLER_37_151 VGND VGND VPWR VPWR sky130_fd_sc_hd__fill_1
X_2198_ tag_raw\[5\] net491 net51 VGND VGND VPWR VPWR _0202_ sky130_fd_sc_hd__mux2_1
XFILLER_52_110 VPWR VGND VPWR VGND sky130_ef_sc_hd__decap_12
XFILLER_25_379 VPWR VGND VPWR VGND sky130_ef_sc_hd__decap_12
XFILLER_88_530 VGND VGND VPWR VPWR sky130_fd_sc_hd__fill_2
XFILLER_0_445 VGND VGND VPWR VPWR sky130_fd_sc_hd__decap_3
Xhold20 u_tx_fifo.mem\[10\]\[5\] VGND VGND VPWR VPWR net176 sky130_fd_sc_hd__dlygate4sd3_1
XFILLER_0_489 VPWR VGND VPWR VGND sky130_ef_sc_hd__decap_12
Xhold31 u_rx_fifo.mem\[12\]\[5\] VGND VGND VPWR VPWR net187 sky130_fd_sc_hd__dlygate4sd3_1
Xhold53 u_tx_fifo.mem\[6\]\[5\] VGND VGND VPWR VPWR net209 sky130_fd_sc_hd__dlygate4sd3_1
Xhold42 u_tx_fifo.mem\[0\]\[5\] VGND VGND VPWR VPWR net198 sky130_fd_sc_hd__dlygate4sd3_1
Xhold64 u_rx_fifo.mem\[14\]\[5\] VGND VGND VPWR VPWR net220 sky130_fd_sc_hd__dlygate4sd3_1
Xhold86 u_rx_fifo.mem\[4\]\[7\] VGND VGND VPWR VPWR net242 sky130_fd_sc_hd__dlygate4sd3_1
Xhold75 u_tx_fifo.mem\[15\]\[0\] VGND VGND VPWR VPWR net231 sky130_fd_sc_hd__dlygate4sd3_1
XPHY_EDGE_ROW_11_Left_105 VGND VGND VPWR VPWR sky130_fd_sc_hd__decap_3
Xhold97 u_rx_fifo.mem\[10\]\[6\] VGND VGND VPWR VPWR net253 sky130_fd_sc_hd__dlygate4sd3_1
XTAP_TAPCELL_ROW_74_904 VGND VPWR sky130_fd_sc_hd__tapvpwrvgnd_1
XFILLER_75_279 VGND VGND VPWR VPWR sky130_fd_sc_hd__fill_1
XTAP_TAPCELL_ROW_46_639 VGND VPWR sky130_fd_sc_hd__tapvpwrvgnd_1
XFILLER_83_290 VGND VGND VPWR VPWR sky130_fd_sc_hd__decap_6
XFILLER_16_346 VPWR VGND VPWR VGND sky130_ef_sc_hd__decap_12
XFILLER_28_195 VGND VGND VPWR VPWR sky130_fd_sc_hd__fill_1
XFILLER_43_110 VGND VGND VPWR VPWR sky130_fd_sc_hd__fill_2
XTAP_TAPCELL_ROW_82_981 VGND VPWR sky130_fd_sc_hd__tapvpwrvgnd_1
XFILLER_8_501 VPWR VGND VPWR VGND sky130_ef_sc_hd__decap_12
XFILLER_61_51 VGND VGND VPWR VPWR sky130_fd_sc_hd__decap_4
XFILLER_8_545 VGND VGND VPWR VPWR sky130_fd_sc_hd__decap_8
XPHY_EDGE_ROW_20_Left_114 VGND VGND VPWR VPWR sky130_fd_sc_hd__decap_3
X_3170_ net34 net247 _1586_ VGND VGND VPWR VPWR _0650_ sky130_fd_sc_hd__mux2_1
X_2121_ _0971_ _0998_ VGND VGND VPWR VPWR _0999_ sky130_fd_sc_hd__xnor2_4
XFILLER_39_427 VGND VGND VPWR VPWR sky130_fd_sc_hd__fill_1
XTAP_TAPCELL_ROW_1_209 VGND VPWR sky130_fd_sc_hd__tapvpwrvgnd_1
X_2052_ net271 net81 _0959_ VGND VGND VPWR VPWR _0159_ sky130_fd_sc_hd__mux2_1
XFILLER_19_195 VGND VGND VPWR VPWR sky130_fd_sc_hd__decap_4
XFILLER_34_132 VGND VGND VPWR VPWR sky130_fd_sc_hd__decap_8
XTAP_TAPCELL_ROW_17_363 VGND VPWR sky130_fd_sc_hd__tapvpwrvgnd_1
XFILLER_22_338 VGND VGND VPWR VPWR sky130_fd_sc_hd__decap_3
X_2954_ net86 _1479_ _1480_ VGND VGND VPWR VPWR _0540_ sky130_fd_sc_hd__nor3_1
X_2885_ net32 net315 _1438_ VGND VGND VPWR VPWR _0513_ sky130_fd_sc_hd__mux2_1
XFILLER_30_360 VGND VGND VPWR VPWR sky130_fd_sc_hd__decap_4
X_1905_ u_parser.u_packet_encoder.tag_latched\[37\] _0896_ _0900_ u_parser.u_packet_encoder.tag_latched\[29\]
+ _0928_ VGND VGND VPWR VPWR _0930_ sky130_fd_sc_hd__a221o_1
X_1836_ parser_tx_valid card_event VGND VGND VPWR VPWR _0883_ sky130_fd_sc_hd__nand2b_1
XPHY_EDGE_ROW_6_Right_6 VGND VGND VPWR VPWR sky130_fd_sc_hd__decap_3
X_1767_ u_uart_tx.bit_index\[0\] u_uart_tx.bit_index\[1\] _0829_ VGND VGND VPWR VPWR
+ _0830_ sky130_fd_sc_hd__and3_1
X_3506_ clknet_leaf_29_clk _0333_ net136 VGND VGND VPWR VPWR u_parser.u_decoder.timeout_count\[8\]
+ sky130_fd_sc_hd__dfrtp_1
X_1698_ u_rx_fifo.mem\[0\]\[2\] u_rx_fifo.mem\[1\]\[2\] u_rx_fifo.mem\[2\]\[2\] u_rx_fifo.mem\[3\]\[2\]
+ net153 net149 VGND VGND VPWR VPWR _0765_ sky130_fd_sc_hd__mux4_1
X_3437_ clknet_leaf_17_clk _0270_ VGND VGND VPWR VPWR u_rx_fifo.mem\[1\]\[5\] sky130_fd_sc_hd__dfxtp_1
X_3368_ clknet_leaf_59_clk _0201_ net93 VGND VGND VPWR VPWR u_parser.u_packet_encoder.tag_latched\[4\]
+ sky130_fd_sc_hd__dfrtp_1
X_2319_ _0682_ _1118_ _1121_ _1122_ VGND VGND VPWR VPWR _1123_ sky130_fd_sc_hd__a22o_1
XFILLER_66_29 VPWR VGND VPWR VGND sky130_ef_sc_hd__decap_12
X_3299_ clknet_leaf_1_clk _0135_ VGND VGND VPWR VPWR u_tx_fifo.mem\[14\]\[2\] sky130_fd_sc_hd__dfxtp_1
XTAP_TAPCELL_ROW_84_1000 VGND VPWR sky130_fd_sc_hd__tapvpwrvgnd_1
XFILLER_72_205 VGND VGND VPWR VPWR sky130_fd_sc_hd__decap_8
XFILLER_72_249 VGND VGND VPWR VPWR sky130_fd_sc_hd__decap_3
XFILLER_13_316 VGND VGND VPWR VPWR sky130_fd_sc_hd__decap_3
XTAP_TAPCELL_ROW_43_609 VGND VPWR sky130_fd_sc_hd__tapvpwrvgnd_1
XFILLER_15_44 VGND VGND VPWR VPWR sky130_fd_sc_hd__fill_1
XTAP_TAPCELL_ROW_51_686 VGND VPWR sky130_fd_sc_hd__tapvpwrvgnd_1
XFILLER_21_393 VGND VGND VPWR VPWR sky130_fd_sc_hd__decap_3
XFILLER_0_253 VPWR VGND VPWR VGND sky130_ef_sc_hd__decap_12
XFILLER_76_533 VPWR VGND VPWR VGND sky130_ef_sc_hd__decap_12
XFILLER_0_297 VGND VGND VPWR VPWR sky130_fd_sc_hd__decap_8
XFILLER_91_503 VGND VGND VPWR VPWR sky130_fd_sc_hd__fill_1
XTAP_TAPCELL_ROW_59_764 VGND VPWR sky130_fd_sc_hd__tapvpwrvgnd_1
XFILLER_29_493 VGND VGND VPWR VPWR sky130_fd_sc_hd__fill_2
XTAP_TAPCELL_ROW_14_333 VGND VPWR sky130_fd_sc_hd__tapvpwrvgnd_1
XFILLER_72_83 VGND VGND VPWR VPWR sky130_fd_sc_hd__fill_1
XPHY_EDGE_ROW_59_Right_59 VGND VGND VPWR VPWR sky130_fd_sc_hd__decap_3
X_2670_ u_parser.u_decoder.decoded_checksum_calc\[2\] _1350_ net12 VGND VGND VPWR
+ VPWR _0386_ sky130_fd_sc_hd__mux2_1
X_1621_ u_uart_rx.sample_div_count\[1\] u_uart_rx.sample_div_count\[3\] VGND VGND
+ VPWR VPWR _0691_ sky130_fd_sc_hd__nand2_1
X_3222_ clknet_leaf_16_clk _0058_ VGND VGND VPWR VPWR u_rx_fifo.mem\[7\]\[5\] sky130_fd_sc_hd__dfxtp_1
X_3153_ net59 _1574_ _1582_ _1583_ VGND VGND VPWR VPWR _0636_ sky130_fd_sc_hd__a31o_1
XFILLER_79_382 VGND VGND VPWR VPWR sky130_fd_sc_hd__decap_8
XPHY_EDGE_ROW_68_Right_68 VGND VGND VPWR VPWR sky130_fd_sc_hd__decap_3
X_2104_ tag_raw\[32\] _0981_ VGND VGND VPWR VPWR _0982_ sky130_fd_sc_hd__xnor2_4
X_3084_ u_uart_rx.sample_div_count\[8\] u_uart_rx.sample_div_count\[9\] u_uart_rx.sample_div_count\[10\]
+ _1536_ VGND VGND VPWR VPWR _1543_ sky130_fd_sc_hd__and4_1
X_2035_ net33 net250 _0957_ VGND VGND VPWR VPWR _0144_ sky130_fd_sc_hd__mux2_1
XFILLER_50_433 VGND VGND VPWR VPWR sky130_fd_sc_hd__fill_1
XPHY_EDGE_ROW_77_Right_77 VGND VGND VPWR VPWR sky130_fd_sc_hd__decap_3
X_2937_ u_uart_rx.low_count\[0\] _0844_ net86 VGND VGND VPWR VPWR _1470_ sky130_fd_sc_hd__a21oi_1
X_2868_ net21 net361 _1436_ VGND VGND VPWR VPWR _0498_ sky130_fd_sc_hd__mux2_1
Xhold320 u_parser.u_decoder.decoded_payload\[10\] VGND VGND VPWR VPWR net476 sky130_fd_sc_hd__dlygate4sd3_1
X_2799_ _1371_ _1407_ VGND VGND VPWR VPWR _1410_ sky130_fd_sc_hd__nor2_2
X_1819_ net621 _0866_ VGND VGND VPWR VPWR _0869_ sky130_fd_sc_hd__nand2_1
Xhold353 u_uart_rx.rx_shift\[0\] VGND VGND VPWR VPWR net509 sky130_fd_sc_hd__dlygate4sd3_1
Xhold342 u_uart_rx.rx_shift\[4\] VGND VGND VPWR VPWR net498 sky130_fd_sc_hd__dlygate4sd3_1
XFILLER_89_113 VGND VGND VPWR VPWR sky130_fd_sc_hd__fill_2
Xhold331 u_parser.u_packet_encoder.tag_latched\[37\] VGND VGND VPWR VPWR net487 sky130_fd_sc_hd__dlygate4sd3_1
XFILLER_89_135 VGND VGND VPWR VPWR sky130_fd_sc_hd__fill_1
Xhold386 u_uart_rx.low_count\[16\] VGND VGND VPWR VPWR net542 sky130_fd_sc_hd__dlygate4sd3_1
Xhold375 u_parser.u_packet_encoder.tag_latched\[7\] VGND VGND VPWR VPWR net531 sky130_fd_sc_hd__dlygate4sd3_1
Xhold364 u_parser.u_packet_encoder.tag_latched\[32\] VGND VGND VPWR VPWR net520 sky130_fd_sc_hd__dlygate4sd3_1
XPHY_EDGE_ROW_86_Right_86 VGND VGND VPWR VPWR sky130_fd_sc_hd__decap_3
XFILLER_77_39 VPWR VGND VPWR VGND sky130_ef_sc_hd__decap_12
Xhold397 u_parser.u_packet_encoder.crc_latched\[3\] VGND VGND VPWR VPWR net553 sky130_fd_sc_hd__dlygate4sd3_1
XFILLER_58_533 VPWR VGND VPWR VGND sky130_ef_sc_hd__decap_12
XFILLER_18_408 VPWR VGND VPWR VGND sky130_ef_sc_hd__decap_12
XFILLER_93_27 VGND VGND VPWR VPWR sky130_fd_sc_hd__fill_1
XFILLER_45_238 VPWR VGND VPWR VGND sky130_ef_sc_hd__decap_12
XTAP_TAPCELL_ROW_56_734 VGND VPWR sky130_fd_sc_hd__tapvpwrvgnd_1
XTAP_TAPCELL_ROW_28_469 VGND VPWR sky130_fd_sc_hd__tapvpwrvgnd_1
XFILLER_13_113 VGND VGND VPWR VPWR sky130_fd_sc_hd__fill_1
XFILLER_41_411 VGND VGND VPWR VPWR sky130_fd_sc_hd__fill_2
XFILLER_53_260 VGND VGND VPWR VPWR sky130_fd_sc_hd__decap_6
XFILLER_53_293 VGND VGND VPWR VPWR sky130_fd_sc_hd__fill_1
XTAP_TAPCELL_ROW_11_303 VGND VPWR sky130_fd_sc_hd__tapvpwrvgnd_1
XFILLER_42_53 VPWR VGND VPWR VGND sky130_ef_sc_hd__decap_12
XFILLER_42_97 VPWR VGND VPWR VGND sky130_ef_sc_hd__decap_12
XFILLER_5_367 VPWR VGND VPWR VGND sky130_ef_sc_hd__decap_12
XFILLER_76_363 VGND VGND VPWR VPWR sky130_fd_sc_hd__fill_1
XFILLER_51_219 VGND VGND VPWR VPWR sky130_fd_sc_hd__decap_4
X_3771_ clknet_leaf_15_clk _0589_ VGND VGND VPWR VPWR u_rx_fifo.mem\[2\]\[4\] sky130_fd_sc_hd__dfxtp_1
XFILLER_32_477 VPWR VGND VPWR VGND sky130_ef_sc_hd__decap_12
X_2722_ net562 _0744_ _1374_ VGND VGND VPWR VPWR _0414_ sky130_fd_sc_hd__mux2_1
XFILLER_73_3 VPWR VGND VPWR VGND sky130_ef_sc_hd__decap_12
X_2653_ net452 _1337_ net7 VGND VGND VPWR VPWR _0382_ sky130_fd_sc_hd__mux2_1
X_2584_ u_parser.u_decoder.ascii_buf\[3\]\[3\] u_parser.u_decoder.ascii_buf\[3\]\[7\]
+ u_parser.u_decoder.ascii_buf\[3\]\[4\] u_parser.u_decoder.ascii_buf\[3\]\[6\] VGND
+ VGND VPWR VPWR _1283_ sky130_fd_sc_hd__or4b_1
X_1604_ net605 VGND VGND VPWR VPWR _0674_ sky130_fd_sc_hd__inv_2
Xfanout107 net108 VGND VGND VPWR VPWR net107 sky130_fd_sc_hd__clkbuf_4
Xfanout129 net130 VGND VGND VPWR VPWR net129 sky130_fd_sc_hd__buf_2
Xfanout118 net119 VGND VGND VPWR VPWR net118 sky130_fd_sc_hd__clkbuf_4
XFILLER_86_138 VGND VGND VPWR VPWR sky130_fd_sc_hd__fill_2
X_3205_ clknet_leaf_1_clk _0041_ VGND VGND VPWR VPWR u_tx_fifo.mem\[7\]\[4\] sky130_fd_sc_hd__dfxtp_1
X_3136_ net59 net509 _1571_ VGND VGND VPWR VPWR _0631_ sky130_fd_sc_hd__mux2_1
XFILLER_55_503 VGND VGND VPWR VPWR sky130_fd_sc_hd__fill_1
X_3067_ _0665_ _1528_ _1531_ VGND VGND VPWR VPWR _0602_ sky130_fd_sc_hd__a21boi_1
XFILLER_82_377 VPWR VGND VPWR VGND sky130_ef_sc_hd__decap_12
X_2018_ net32 net363 _0955_ VGND VGND VPWR VPWR _0129_ sky130_fd_sc_hd__mux2_1
XTAP_TAPCELL_ROW_53_704 VGND VPWR sky130_fd_sc_hd__tapvpwrvgnd_1
XFILLER_70_517 VPWR VGND VPWR VGND sky130_ef_sc_hd__decap_12
XFILLER_23_400 VGND VGND VPWR VPWR sky130_fd_sc_hd__decap_8
XTAP_TAPCELL_ROW_25_439 VGND VPWR sky130_fd_sc_hd__tapvpwrvgnd_1
XFILLER_35_293 VGND VGND VPWR VPWR sky130_fd_sc_hd__fill_1
XTAP_TAPCELL_ROW_61_781 VGND VPWR sky130_fd_sc_hd__tapvpwrvgnd_1
XFILLER_88_27 VGND VGND VPWR VPWR sky130_fd_sc_hd__fill_1
XFILLER_12_89 VGND VGND VPWR VPWR sky130_fd_sc_hd__fill_1
Xhold161 u_tx_fifo.mem\[13\]\[6\] VGND VGND VPWR VPWR net317 sky130_fd_sc_hd__dlygate4sd3_1
Xhold150 u_rx_fifo.mem\[4\]\[2\] VGND VGND VPWR VPWR net306 sky130_fd_sc_hd__dlygate4sd3_1
Xhold183 u_rx_fifo.mem\[2\]\[7\] VGND VGND VPWR VPWR net339 sky130_fd_sc_hd__dlygate4sd3_1
Xhold194 u_tx_fifo.mem\[15\]\[4\] VGND VGND VPWR VPWR net350 sky130_fd_sc_hd__dlygate4sd3_1
Xhold172 u_rx_fifo.mem\[15\]\[1\] VGND VGND VPWR VPWR net328 sky130_fd_sc_hd__dlygate4sd3_1
XFILLER_58_341 VGND VGND VPWR VPWR sky130_fd_sc_hd__decap_3
XFILLER_92_119 VGND VGND VPWR VPWR sky130_fd_sc_hd__decap_6
XFILLER_58_363 VGND VGND VPWR VPWR sky130_fd_sc_hd__fill_1
XFILLER_41_230 VPWR VGND VPWR VGND sky130_ef_sc_hd__decap_12
XFILLER_14_477 VPWR VGND VPWR VGND sky130_ef_sc_hd__decap_12
XFILLER_64_377 VGND VGND VPWR VPWR sky130_fd_sc_hd__fill_1
XFILLER_17_271 VGND VGND VPWR VPWR sky130_fd_sc_hd__decap_4
XFILLER_32_241 VGND VGND VPWR VPWR sky130_fd_sc_hd__fill_2
XTAP_TAPCELL_ROW_22_409 VGND VPWR sky130_fd_sc_hd__tapvpwrvgnd_1
X_3823_ clknet_leaf_58_clk _0639_ VGND VGND VPWR VPWR u_tx_fifo.mem\[0\]\[0\] sky130_fd_sc_hd__dfxtp_1
X_3754_ clknet_leaf_0_clk _0572_ VGND VGND VPWR VPWR u_tx_fifo.mem\[15\]\[3\] sky130_fd_sc_hd__dfxtp_1
X_3685_ clknet_leaf_58_clk _0512_ VGND VGND VPWR VPWR u_tx_fifo.mem\[1\]\[3\] sky130_fd_sc_hd__dfxtp_1
XTAP_TAPCELL_ROW_30_486 VGND VPWR sky130_fd_sc_hd__tapvpwrvgnd_1
X_2705_ _1142_ _1371_ net493 VGND VGND VPWR VPWR _0399_ sky130_fd_sc_hd__o21a_1
X_2636_ net465 _1323_ net12 VGND VGND VPWR VPWR _0379_ sky130_fd_sc_hd__mux2_1
X_2567_ u_parser.u_decoder.ascii_buf\[4\]\[3\] u_parser.u_decoder.ascii_buf\[4\]\[4\]
+ u_parser.u_decoder.ascii_buf\[4\]\[7\] u_parser.u_decoder.ascii_buf\[4\]\[6\] VGND
+ VGND VPWR VPWR _1270_ sky130_fd_sc_hd__or4b_1
X_2498_ u_parser.u_decoder.ascii_buf\[8\]\[5\] _1213_ _1214_ net47 VGND VGND VPWR
+ VPWR _1216_ sky130_fd_sc_hd__a211o_1
XFILLER_59_138 VGND VGND VPWR VPWR sky130_fd_sc_hd__fill_1
XFILLER_55_333 VGND VGND VPWR VPWR sky130_fd_sc_hd__decap_3
XFILLER_74_29 VPWR VGND VPWR VGND sky130_ef_sc_hd__decap_12
XFILLER_82_152 VGND VGND VPWR VPWR sky130_fd_sc_hd__decap_6
XFILLER_82_141 VGND VGND VPWR VPWR sky130_fd_sc_hd__fill_2
X_3119_ _1559_ _1560_ VGND VGND VPWR VPWR _0625_ sky130_fd_sc_hd__and2_1
XTAP_TAPCELL_ROW_38_564 VGND VPWR sky130_fd_sc_hd__tapvpwrvgnd_1
XFILLER_23_241 VGND VGND VPWR VPWR sky130_fd_sc_hd__fill_1
XFILLER_23_274 VGND VGND VPWR VPWR sky130_fd_sc_hd__decap_6
XFILLER_7_429 VPWR VGND VPWR VGND sky130_ef_sc_hd__decap_12
XFILLER_2_101 VGND VGND VPWR VPWR sky130_fd_sc_hd__decap_3
XFILLER_3_3 VPWR VGND VPWR VGND sky130_ef_sc_hd__decap_12
XFILLER_78_447 VGND VGND VPWR VPWR sky130_fd_sc_hd__decap_3
XFILLER_48_41 VPWR VGND VPWR VGND sky130_ef_sc_hd__decap_12
XFILLER_93_417 VGND VGND VPWR VPWR sky130_fd_sc_hd__decap_3
XFILLER_48_85 VPWR VGND VPWR VGND sky130_ef_sc_hd__decap_12
XFILLER_65_108 VGND VGND VPWR VPWR sky130_fd_sc_hd__decap_4
XFILLER_0_15 VPWR VGND VPWR VGND sky130_ef_sc_hd__decap_12
XFILLER_19_525 VPWR VGND VPWR VGND sky130_ef_sc_hd__decap_12
XPHY_EDGE_ROW_85_Left_179 VGND VGND VPWR VPWR sky130_fd_sc_hd__decap_3
XFILLER_61_369 VGND VGND VPWR VPWR sky130_fd_sc_hd__fill_2
XTAP_TAPCELL_ROW_72_887 VGND VPWR sky130_fd_sc_hd__tapvpwrvgnd_1
XFILLER_80_83 VGND VGND VPWR VPWR sky130_fd_sc_hd__fill_1
X_3470_ clknet_leaf_43_clk _0297_ net109 VGND VGND VPWR VPWR tag_raw\[24\] sky130_fd_sc_hd__dfrtp_1
X_2421_ net3 _1158_ _1160_ VGND VGND VPWR VPWR _0327_ sky130_fd_sc_hd__and3_1
X_2352_ tag_raw\[5\] net457 net16 VGND VGND VPWR VPWR _0278_ sky130_fd_sc_hd__mux2_1
XFILLER_36_3 VPWR VGND VPWR VGND sky130_ef_sc_hd__decap_12
X_2283_ _0682_ _1086_ _1089_ _1090_ VGND VGND VPWR VPWR _1091_ sky130_fd_sc_hd__a22o_1
XFILLER_69_469 VPWR VGND VPWR VGND sky130_ef_sc_hd__decap_12
XTAP_TAPCELL_ROW_35_534 VGND VPWR sky130_fd_sc_hd__tapvpwrvgnd_1
X_3806_ clknet_leaf_18_clk _0624_ net123 VGND VGND VPWR VPWR rx_fifo_in_data\[7\]
+ sky130_fd_sc_hd__dfrtp_1
X_1998_ net203 net33 _0952_ VGND VGND VPWR VPWR _0112_ sky130_fd_sc_hd__mux2_1
X_3737_ clknet_leaf_63_clk _0561_ VGND VGND VPWR VPWR u_tx_fifo.mem\[8\]\[0\] sky130_fd_sc_hd__dfxtp_1
XFILLER_20_288 VGND VGND VPWR VPWR sky130_fd_sc_hd__decap_3
X_3668_ clknet_leaf_65_clk _0495_ VGND VGND VPWR VPWR u_tx_fifo.mem\[9\]\[2\] sky130_fd_sc_hd__dfxtp_1
X_2619_ _1308_ _1309_ VGND VGND VPWR VPWR _1310_ sky130_fd_sc_hd__nand2_1
X_3599_ clknet_leaf_4_clk _0426_ net96 VGND VGND VPWR VPWR u_parser.u_decoder.ascii_buf\[8\]\[2\]
+ sky130_fd_sc_hd__dfrtp_1
XTAP_TAPCELL_ROW_87_1031 VGND VPWR sky130_fd_sc_hd__tapvpwrvgnd_1
XFILLER_16_517 VGND VGND VPWR VPWR sky130_fd_sc_hd__fill_1
XFILLER_50_53 VPWR VGND VPWR VGND sky130_ef_sc_hd__decap_12
XFILLER_50_97 VPWR VGND VPWR VGND sky130_ef_sc_hd__decap_12
XFILLER_59_51 VGND VGND VPWR VPWR sky130_fd_sc_hd__decap_4
XFILLER_78_244 VGND VGND VPWR VPWR sky130_fd_sc_hd__decap_8
XFILLER_59_84 VGND VGND VPWR VPWR sky130_fd_sc_hd__decap_3
XFILLER_59_95 VGND VGND VPWR VPWR sky130_fd_sc_hd__decap_6
XTAP_TAPCELL_ROW_77_935 VGND VPWR sky130_fd_sc_hd__tapvpwrvgnd_1
XFILLER_46_141 VGND VGND VPWR VPWR sky130_fd_sc_hd__decap_6
XFILLER_74_483 VGND VGND VPWR VPWR sky130_fd_sc_hd__fill_2
X_2970_ u_uart_rx.low_count\[1\] u_uart_rx.low_count\[3\] u_uart_rx.low_count\[2\]
+ u_uart_rx.low_count\[4\] VGND VGND VPWR VPWR _1490_ sky130_fd_sc_hd__and4_1
XTAP_TAPCELL_ROW_32_504 VGND VPWR sky130_fd_sc_hd__tapvpwrvgnd_1
XFILLER_34_369 VGND VGND VPWR VPWR sky130_fd_sc_hd__fill_1
XFILLER_30_531 VGND VGND VPWR VPWR sky130_fd_sc_hd__fill_1
X_1921_ net291 net83 _0941_ VGND VGND VPWR VPWR _0046_ sky130_fd_sc_hd__mux2_1
X_1852_ net264 net82 _0888_ VGND VGND VPWR VPWR _0030_ sky130_fd_sc_hd__mux2_1
XFILLER_30_553 VGND VGND VPWR VPWR sky130_fd_sc_hd__fill_2
X_1783_ u_uart_rx.break_detect u_uart_rx.low_count\[23\] u_uart_rx.low_count\[22\]
+ u_uart_rx.low_count\[21\] VGND VGND VPWR VPWR _0843_ sky130_fd_sc_hd__or4_1
XTAP_TAPCELL_ROW_40_581 VGND VPWR sky130_fd_sc_hd__tapvpwrvgnd_1
X_3522_ clknet_leaf_59_clk _0349_ net93 VGND VGND VPWR VPWR u_parser.u_decoder.decoded_payload\[5\]
+ sky130_fd_sc_hd__dfrtp_1
Xfanout9 _1191_ VGND VGND VPWR VPWR net9 sky130_fd_sc_hd__clkbuf_2
X_3453_ clknet_leaf_59_clk _0280_ net97 VGND VGND VPWR VPWR tag_raw\[7\] sky130_fd_sc_hd__dfrtp_1
X_2404_ u_parser.u_decoder.index\[2\] _1141_ _0964_ VGND VGND VPWR VPWR _1148_ sky130_fd_sc_hd__mux2_1
X_3384_ clknet_leaf_59_clk _0217_ net93 VGND VGND VPWR VPWR u_parser.u_packet_encoder.tag_latched\[20\]
+ sky130_fd_sc_hd__dfrtp_1
XFILLER_69_233 VGND VGND VPWR VPWR sky130_fd_sc_hd__fill_2
XFILLER_69_244 VPWR VGND VPWR VGND sky130_ef_sc_hd__decap_12
X_2335_ net77 net398 _1132_ VGND VGND VPWR VPWR _0269_ sky130_fd_sc_hd__mux2_1
X_2266_ net447 _1075_ net49 VGND VGND VPWR VPWR _0257_ sky130_fd_sc_hd__mux2_1
X_2197_ tag_raw\[4\] net533 net51 VGND VGND VPWR VPWR _0201_ sky130_fd_sc_hd__mux2_1
XFILLER_52_122 VPWR VGND VPWR VGND sky130_ef_sc_hd__decap_12
XFILLER_20_56 VGND VGND VPWR VPWR sky130_fd_sc_hd__fill_1
XTAP_TAPCELL_ROW_93_1090 VGND VPWR sky130_fd_sc_hd__tapvpwrvgnd_1
XFILLER_88_553 VGND VGND VPWR VPWR sky130_fd_sc_hd__fill_2
Xhold10 u_tx_fifo.mem\[10\]\[7\] VGND VGND VPWR VPWR net166 sky130_fd_sc_hd__dlygate4sd3_1
Xhold32 u_tx_fifo.mem\[4\]\[7\] VGND VGND VPWR VPWR net188 sky130_fd_sc_hd__dlygate4sd3_1
Xhold21 u_tx_fifo.mem\[6\]\[2\] VGND VGND VPWR VPWR net177 sky130_fd_sc_hd__dlygate4sd3_1
Xhold54 u_rx_fifo.mem\[0\]\[0\] VGND VGND VPWR VPWR net210 sky130_fd_sc_hd__dlygate4sd3_1
Xhold43 u_tx_fifo.mem\[8\]\[2\] VGND VGND VPWR VPWR net199 sky130_fd_sc_hd__dlygate4sd3_1
Xhold65 u_tx_fifo.mem\[14\]\[4\] VGND VGND VPWR VPWR net221 sky130_fd_sc_hd__dlygate4sd3_1
Xhold76 u_tx_fifo.mem\[14\]\[7\] VGND VGND VPWR VPWR net232 sky130_fd_sc_hd__dlygate4sd3_1
Xhold98 u_tx_fifo.mem\[11\]\[4\] VGND VGND VPWR VPWR net254 sky130_fd_sc_hd__dlygate4sd3_1
XFILLER_28_141 VGND VGND VPWR VPWR sky130_fd_sc_hd__decap_4
Xhold87 u_tx_fifo.mem\[0\]\[6\] VGND VGND VPWR VPWR net243 sky130_fd_sc_hd__dlygate4sd3_1
XTAP_TAPCELL_ROW_74_905 VGND VPWR sky130_fd_sc_hd__tapvpwrvgnd_1
XFILLER_28_163 VGND VGND VPWR VPWR sky130_fd_sc_hd__decap_3
XFILLER_16_358 VGND VGND VPWR VPWR sky130_fd_sc_hd__decap_6
XFILLER_56_494 VGND VGND VPWR VPWR sky130_fd_sc_hd__decap_3
XTAP_TAPCELL_ROW_82_982 VGND VPWR sky130_fd_sc_hd__tapvpwrvgnd_1
XFILLER_12_553 VGND VGND VPWR VPWR sky130_fd_sc_hd__fill_2
XFILLER_12_531 VGND VGND VPWR VPWR sky130_fd_sc_hd__fill_1
XFILLER_8_513 VPWR VGND VPWR VGND sky130_ef_sc_hd__decap_12
X_2120_ tag_raw\[38\] tag_raw\[30\] VGND VGND VPWR VPWR _0998_ sky130_fd_sc_hd__xor2_2
XFILLER_66_225 VGND VGND VPWR VPWR sky130_fd_sc_hd__decap_4
XFILLER_86_93 VGND VGND VPWR VPWR sky130_fd_sc_hd__decap_3
XFILLER_54_409 VGND VGND VPWR VPWR sky130_fd_sc_hd__fill_1
X_2051_ net235 net83 _0959_ VGND VGND VPWR VPWR _0158_ sky130_fd_sc_hd__mux2_1
X_2953_ u_uart_rx.low_count\[6\] u_uart_rx.low_count\[5\] _1476_ VGND VGND VPWR VPWR
+ _1480_ sky130_fd_sc_hd__and3_1
XTAP_TAPCELL_ROW_17_364 VGND VPWR sky130_fd_sc_hd__tapvpwrvgnd_1
X_1904_ _0895_ _0905_ _0904_ VGND VGND VPWR VPWR _0929_ sky130_fd_sc_hd__o21ai_1
XFILLER_15_391 VGND VGND VPWR VPWR sky130_fd_sc_hd__fill_1
X_2884_ net34 net386 _1438_ VGND VGND VPWR VPWR _0512_ sky130_fd_sc_hd__mux2_1
XFILLER_30_383 VGND VGND VPWR VPWR sky130_fd_sc_hd__fill_1
X_1835_ parser_tx_valid _0880_ VGND VGND VPWR VPWR _0882_ sky130_fd_sc_hd__nand2_2
X_1766_ _0828_ VGND VGND VPWR VPWR _0829_ sky130_fd_sc_hd__inv_2
X_3505_ clknet_leaf_28_clk _0332_ net137 VGND VGND VPWR VPWR u_parser.u_decoder.timeout_count\[7\]
+ sky130_fd_sc_hd__dfrtp_1
XFILLER_89_317 VPWR VGND VPWR VGND sky130_ef_sc_hd__decap_12
X_1697_ net58 _0761_ u_rx_fifo.rd_ptr\[3\] VGND VGND VPWR VPWR _0764_ sky130_fd_sc_hd__o21a_1
X_3436_ clknet_leaf_15_clk _0269_ VGND VGND VPWR VPWR u_rx_fifo.mem\[1\]\[4\] sky130_fd_sc_hd__dfxtp_1
X_3367_ clknet_leaf_48_clk net551 net103 VGND VGND VPWR VPWR u_parser.u_packet_encoder.tag_latched\[3\]
+ sky130_fd_sc_hd__dfrtp_1
X_2318_ net60 _1119_ u_tx_fifo.rd_ptr\[3\] VGND VGND VPWR VPWR _1122_ sky130_fd_sc_hd__o21a_1
XFILLER_57_225 VGND VGND VPWR VPWR sky130_fd_sc_hd__fill_1
X_3298_ clknet_leaf_0_clk _0134_ VGND VGND VPWR VPWR u_tx_fifo.mem\[14\]\[1\] sky130_fd_sc_hd__dfxtp_1
X_2249_ net194 net29 _1067_ VGND VGND VPWR VPWR _0248_ sky130_fd_sc_hd__mux2_1
XTAP_TAPCELL_ROW_84_1001 VGND VPWR sky130_fd_sc_hd__tapvpwrvgnd_1
XFILLER_82_29 VPWR VGND VPWR VGND sky130_ef_sc_hd__decap_12
XFILLER_25_122 VGND VGND VPWR VPWR sky130_fd_sc_hd__fill_1
XFILLER_25_166 VGND VGND VPWR VPWR sky130_fd_sc_hd__fill_2
XFILLER_15_34 VGND VGND VPWR VPWR sky130_fd_sc_hd__fill_1
XFILLER_40_158 VGND VGND VPWR VPWR sky130_fd_sc_hd__decap_6
XTAP_TAPCELL_ROW_51_687 VGND VPWR sky130_fd_sc_hd__tapvpwrvgnd_1
XFILLER_5_505 VPWR VGND VPWR VGND sky130_ef_sc_hd__decap_12
XFILLER_31_55 VGND VGND VPWR VPWR sky130_fd_sc_hd__fill_1
XFILLER_0_221 VGND VGND VPWR VPWR sky130_fd_sc_hd__decap_3
XFILLER_88_394 VGND VGND VPWR VPWR sky130_fd_sc_hd__decap_4
XFILLER_0_265 VPWR VGND VPWR VGND sky130_ef_sc_hd__decap_12
XFILLER_76_545 VGND VGND VPWR VPWR sky130_fd_sc_hd__decap_8
XFILLER_56_41 VGND VGND VPWR VPWR sky130_fd_sc_hd__decap_6
XTAP_TAPCELL_ROW_59_765 VGND VPWR sky130_fd_sc_hd__tapvpwrvgnd_1
XFILLER_16_111 VPWR VGND VPWR VGND sky130_ef_sc_hd__decap_12
XFILLER_16_133 VGND VGND VPWR VPWR sky130_fd_sc_hd__decap_3
XFILLER_71_272 VGND VGND VPWR VPWR sky130_fd_sc_hd__fill_1
XFILLER_71_294 VPWR VGND VPWR VGND sky130_ef_sc_hd__decap_12
XTAP_TAPCELL_ROW_14_334 VGND VPWR sky130_fd_sc_hd__tapvpwrvgnd_1
XFILLER_12_361 VGND VGND VPWR VPWR sky130_fd_sc_hd__decap_3
X_1620_ u_uart_rx.sample_div_count\[5\] u_uart_rx.sample_div_count\[4\] u_uart_rx.sample_div_count\[6\]
+ u_uart_rx.sample_div_count\[7\] VGND VGND VPWR VPWR _0690_ sky130_fd_sc_hd__or4b_1
XFILLER_8_365 VPWR VGND VPWR VGND sky130_ef_sc_hd__decap_12
X_3221_ clknet_leaf_13_clk _0057_ VGND VGND VPWR VPWR u_rx_fifo.mem\[7\]\[4\] sky130_fd_sc_hd__dfxtp_1
X_3152_ _1574_ _1582_ u_uart_rx.rx_shift\[5\] VGND VGND VPWR VPWR _1583_ sky130_fd_sc_hd__a21boi_1
XFILLER_39_225 VGND VGND VPWR VPWR sky130_fd_sc_hd__decap_6
XFILLER_67_534 VPWR VGND VPWR VGND sky130_ef_sc_hd__decap_12
X_2103_ tag_raw\[39\] tag_raw\[38\] VGND VGND VPWR VPWR _0981_ sky130_fd_sc_hd__xor2_4
X_3083_ u_uart_rx.sample_div_count\[7\] u_uart_rx.sample_div_count\[8\] u_uart_rx.sample_div_count\[9\]
+ u_uart_rx.sample_div_count\[10\] VGND VGND VPWR VPWR _1542_ sky130_fd_sc_hd__and4_1
X_2034_ net23 net240 _0957_ VGND VGND VPWR VPWR _0143_ sky130_fd_sc_hd__mux2_1
XFILLER_35_453 VGND VGND VPWR VPWR sky130_fd_sc_hd__fill_1
XFILLER_22_114 VGND VGND VPWR VPWR sky130_fd_sc_hd__fill_1
XFILLER_22_136 VGND VGND VPWR VPWR sky130_fd_sc_hd__fill_1
XFILLER_10_309 VPWR VGND VPWR VGND sky130_ef_sc_hd__decap_12
X_2936_ _0661_ net2 _0835_ _1469_ VGND VGND VPWR VPWR _0533_ sky130_fd_sc_hd__o211a_1
X_2867_ net32 net327 _1436_ VGND VGND VPWR VPWR _0497_ sky130_fd_sc_hd__mux2_1
X_1818_ u_rx_fifo.wr_ptr\[1\] _0866_ VGND VGND VPWR VPWR _0868_ sky130_fd_sc_hd__or2_2
Xhold310 u_parser.u_decoder.decoded_payload\[16\] VGND VGND VPWR VPWR net466 sky130_fd_sc_hd__dlygate4sd3_1
X_2798_ _0686_ _1409_ VGND VGND VPWR VPWR _0455_ sky130_fd_sc_hd__nor2_1
Xhold321 u_parser.u_packet_encoder.tag_latched\[12\] VGND VGND VPWR VPWR net477 sky130_fd_sc_hd__dlygate4sd3_1
Xhold332 u_parser.u_decoder.decoded_payload\[39\] VGND VGND VPWR VPWR net488 sky130_fd_sc_hd__dlygate4sd3_1
Xhold343 u_parser.u_decoder.ascii_buf\[3\]\[5\] VGND VGND VPWR VPWR net499 sky130_fd_sc_hd__dlygate4sd3_1
X_1749_ u_parser.u_decoder.index\[0\] u_parser.u_decoder.index\[1\] u_parser.u_decoder.index\[2\]
+ u_parser.u_decoder.index\[3\] VGND VGND VPWR VPWR _0814_ sky130_fd_sc_hd__or4bb_1
Xhold365 u_uart_rx.low_count\[15\] VGND VGND VPWR VPWR net521 sky130_fd_sc_hd__dlygate4sd3_1
Xhold376 u_parser.u_packet_encoder.crc_latched\[6\] VGND VGND VPWR VPWR net532 sky130_fd_sc_hd__dlygate4sd3_1
Xhold387 u_parser.u_packet_encoder.crc_latched\[7\] VGND VGND VPWR VPWR net543 sky130_fd_sc_hd__dlygate4sd3_1
Xhold354 u_parser.u_packet_encoder.tag_latched\[6\] VGND VGND VPWR VPWR net510 sky130_fd_sc_hd__dlygate4sd3_1
XFILLER_89_169 VGND VGND VPWR VPWR sky130_fd_sc_hd__decap_4
XFILLER_77_309 VGND VGND VPWR VPWR sky130_fd_sc_hd__decap_3
Xhold398 u_parser.u_decoder.ascii_buf\[5\]\[4\] VGND VGND VPWR VPWR net554 sky130_fd_sc_hd__dlygate4sd3_1
X_3419_ clknet_leaf_10_clk _0252_ VGND VGND VPWR VPWR u_rx_fifo.mem\[15\]\[3\] sky130_fd_sc_hd__dfxtp_1
XTAP_TAPCELL_ROW_90_1060 VGND VPWR sky130_fd_sc_hd__tapvpwrvgnd_1
XFILLER_58_545 VGND VGND VPWR VPWR sky130_fd_sc_hd__decap_8
XFILLER_85_386 VGND VGND VPWR VPWR sky130_fd_sc_hd__decap_6
XTAP_TAPCELL_ROW_56_735 VGND VPWR sky130_fd_sc_hd__tapvpwrvgnd_1
XFILLER_26_464 VGND VGND VPWR VPWR sky130_fd_sc_hd__decap_3
XFILLER_26_497 VGND VGND VPWR VPWR sky130_fd_sc_hd__decap_4
XTAP_TAPCELL_ROW_11_304 VGND VPWR sky130_fd_sc_hd__tapvpwrvgnd_1
XFILLER_42_65 VPWR VGND VPWR VGND sky130_ef_sc_hd__decap_12
XFILLER_5_379 VPWR VGND VPWR VGND sky130_ef_sc_hd__decap_12
XFILLER_1_541 VPWR VGND VPWR VGND sky130_ef_sc_hd__decap_12
XFILLER_3_15 VPWR VGND VPWR VGND sky130_ef_sc_hd__decap_12
XFILLER_68_309 VPWR VGND VPWR VGND sky130_ef_sc_hd__decap_12
XFILLER_91_301 VGND VGND VPWR VPWR sky130_fd_sc_hd__decap_6
XFILLER_76_353 VGND VGND VPWR VPWR sky130_fd_sc_hd__fill_2
X_3770_ clknet_leaf_14_clk _0588_ VGND VGND VPWR VPWR u_rx_fifo.mem\[2\]\[3\] sky130_fd_sc_hd__dfxtp_1
XFILLER_32_489 VGND VGND VPWR VPWR sky130_fd_sc_hd__fill_1
X_2721_ net594 net35 _1374_ VGND VGND VPWR VPWR _0413_ sky130_fd_sc_hd__mux2_1
X_2652_ _1333_ _1336_ VGND VGND VPWR VPWR _1337_ sky130_fd_sc_hd__and2_1
XFILLER_66_3 VPWR VGND VPWR VGND sky130_ef_sc_hd__decap_12
X_1603_ u_parser.u_decoder.timeout_count\[5\] VGND VGND VPWR VPWR _0673_ sky130_fd_sc_hd__inv_2
X_2583_ u_parser.u_decoder.ascii_buf\[3\]\[4\] u_parser.u_decoder.ascii_buf\[3\]\[5\]
+ _1280_ _1281_ VGND VGND VPWR VPWR _1282_ sky130_fd_sc_hd__and4_1
Xfanout108 net113 VGND VGND VPWR VPWR net108 sky130_fd_sc_hd__clkbuf_2
Xfanout119 net126 VGND VGND VPWR VPWR net119 sky130_fd_sc_hd__buf_2
X_3204_ clknet_leaf_1_clk _0040_ VGND VGND VPWR VPWR u_tx_fifo.mem\[7\]\[3\] sky130_fd_sc_hd__dfxtp_1
X_3135_ _1556_ u_uart_rx.bit_index\[2\] _0703_ VGND VGND VPWR VPWR _1571_ sky130_fd_sc_hd__or3b_1
X_3066_ _1525_ _1530_ VGND VGND VPWR VPWR _1531_ sky130_fd_sc_hd__nor2_1
XFILLER_82_334 VGND VGND VPWR VPWR sky130_fd_sc_hd__fill_1
X_2017_ net33 net321 _0955_ VGND VGND VPWR VPWR _0128_ sky130_fd_sc_hd__mux2_1
XTAP_TAPCELL_ROW_53_705 VGND VPWR sky130_fd_sc_hd__tapvpwrvgnd_1
XFILLER_82_389 VGND VGND VPWR VPWR sky130_fd_sc_hd__decap_8
XFILLER_70_529 VGND VGND VPWR VPWR sky130_fd_sc_hd__decap_3
XFILLER_10_139 VGND VGND VPWR VPWR sky130_fd_sc_hd__fill_1
X_2919_ _1458_ _1459_ VGND VGND VPWR VPWR _0526_ sky130_fd_sc_hd__nor2_1
XTAP_TAPCELL_ROW_61_782 VGND VPWR sky130_fd_sc_hd__tapvpwrvgnd_1
Xhold151 u_rx_fifo.mem\[5\]\[0\] VGND VGND VPWR VPWR net307 sky130_fd_sc_hd__dlygate4sd3_1
Xhold140 u_rx_fifo.mem\[14\]\[4\] VGND VGND VPWR VPWR net296 sky130_fd_sc_hd__dlygate4sd3_1
Xhold162 u_rx_fifo.mem\[15\]\[7\] VGND VGND VPWR VPWR net318 sky130_fd_sc_hd__dlygate4sd3_1
Xhold184 u_rx_fifo.mem\[6\]\[5\] VGND VGND VPWR VPWR net340 sky130_fd_sc_hd__dlygate4sd3_1
Xhold195 u_tx_fifo.mem\[5\]\[2\] VGND VGND VPWR VPWR net351 sky130_fd_sc_hd__dlygate4sd3_1
Xhold173 u_tx_fifo.mem\[6\]\[1\] VGND VGND VPWR VPWR net329 sky130_fd_sc_hd__dlygate4sd3_1
XTAP_TAPCELL_ROW_69_860 VGND VPWR sky130_fd_sc_hd__tapvpwrvgnd_1
XFILLER_18_239 VGND VGND VPWR VPWR sky130_fd_sc_hd__fill_1
XFILLER_46_526 VGND VGND VPWR VPWR sky130_fd_sc_hd__fill_1
XFILLER_41_242 VPWR VGND VPWR VGND sky130_ef_sc_hd__decap_12
XFILLER_14_489 VGND VGND VPWR VPWR sky130_fd_sc_hd__decap_3
XFILLER_53_86 VGND VGND VPWR VPWR sky130_fd_sc_hd__decap_6
XFILLER_5_154 VGND VGND VPWR VPWR sky130_fd_sc_hd__fill_1
XFILLER_1_360 VPWR VGND VPWR VGND sky130_ef_sc_hd__decap_12
XFILLER_1_393 VPWR VGND VPWR VGND sky130_ef_sc_hd__decap_12
XFILLER_68_139 VGND VGND VPWR VPWR sky130_fd_sc_hd__fill_1
X_3822_ clknet_leaf_18_clk _0638_ net123 VGND VGND VPWR VPWR u_uart_rx.rx_shift\[7\]
+ sky130_fd_sc_hd__dfrtp_1
XFILLER_32_253 VGND VGND VPWR VPWR sky130_fd_sc_hd__decap_6
X_3753_ clknet_leaf_66_clk _0571_ VGND VGND VPWR VPWR u_tx_fifo.mem\[15\]\[2\] sky130_fd_sc_hd__dfxtp_1
XTAP_TAPCELL_ROW_30_487 VGND VPWR sky130_fd_sc_hd__tapvpwrvgnd_1
X_3684_ clknet_leaf_4_clk _0511_ VGND VGND VPWR VPWR u_tx_fifo.mem\[1\]\[2\] sky130_fd_sc_hd__dfxtp_1
X_2704_ net561 net42 _1372_ VGND VGND VPWR VPWR _0398_ sky130_fd_sc_hd__mux2_1
X_2635_ u_parser.u_decoder.ascii_buf\[1\]\[3\] _1311_ _1316_ VGND VGND VPWR VPWR _1323_
+ sky130_fd_sc_hd__a21o_1
X_2566_ u_parser.u_decoder.ascii_buf\[4\]\[0\] _1268_ VGND VGND VPWR VPWR _1269_ sky130_fd_sc_hd__nand2_1
X_2497_ net472 _1215_ net7 VGND VGND VPWR VPWR _0348_ sky130_fd_sc_hd__mux2_1
XFILLER_28_515 VPWR VGND VPWR VGND sky130_ef_sc_hd__decap_12
X_3118_ net67 net49 VGND VGND VPWR VPWR _1560_ sky130_fd_sc_hd__or2_1
XFILLER_55_323 VGND VGND VPWR VPWR sky130_fd_sc_hd__fill_1
XTAP_TAPCELL_ROW_66_830 VGND VPWR sky130_fd_sc_hd__tapvpwrvgnd_1
X_3049_ _0688_ _1510_ _1518_ VGND VGND VPWR VPWR _1520_ sky130_fd_sc_hd__and3_1
XTAP_TAPCELL_ROW_38_565 VGND VPWR sky130_fd_sc_hd__tapvpwrvgnd_1
XFILLER_23_231 VGND VGND VPWR VPWR sky130_fd_sc_hd__fill_1
XFILLER_90_29 VPWR VGND VPWR VGND sky130_ef_sc_hd__decap_12
XFILLER_48_53 VPWR VGND VPWR VGND sky130_ef_sc_hd__decap_12
XFILLER_19_537 VPWR VGND VPWR VGND sky130_ef_sc_hd__decap_12
XFILLER_48_97 VPWR VGND VPWR VGND sky130_ef_sc_hd__decap_12
XFILLER_0_27 VGND VGND VPWR VPWR sky130_fd_sc_hd__fill_1
XFILLER_46_345 VGND VGND VPWR VPWR sky130_fd_sc_hd__fill_1
XFILLER_58_194 VGND VGND VPWR VPWR sky130_fd_sc_hd__fill_2
XFILLER_64_41 VPWR VGND VPWR VGND sky130_ef_sc_hd__decap_12
XFILLER_61_337 VGND VGND VPWR VPWR sky130_fd_sc_hd__decap_8
XFILLER_42_551 VGND VGND VPWR VPWR sky130_fd_sc_hd__decap_4
XTAP_TAPCELL_ROW_72_888 VGND VPWR sky130_fd_sc_hd__tapvpwrvgnd_1
Xfanout90 net114 VGND VGND VPWR VPWR net90 sky130_fd_sc_hd__clkbuf_4
X_2420_ _1159_ VGND VGND VPWR VPWR _1160_ sky130_fd_sc_hd__inv_2
X_2351_ tag_raw\[4\] net472 net16 VGND VGND VPWR VPWR _0277_ sky130_fd_sc_hd__mux2_1
X_2282_ net60 _1087_ u_tx_fifo.rd_ptr\[3\] VGND VGND VPWR VPWR _1090_ sky130_fd_sc_hd__o21a_1
XTAP_TAPCELL_ROW_9_290 VGND VPWR sky130_fd_sc_hd__tapvpwrvgnd_1
XFILLER_29_3 VPWR VGND VPWR VGND sky130_ef_sc_hd__decap_12
XFILLER_77_481 VPWR VGND VPWR VGND sky130_ef_sc_hd__decap_12
XFILLER_37_334 VGND VGND VPWR VPWR sky130_fd_sc_hd__fill_2
XFILLER_37_345 VGND VGND VPWR VPWR sky130_fd_sc_hd__decap_4
XFILLER_49_194 VPWR VGND VPWR VGND sky130_ef_sc_hd__decap_12
XTAP_TAPCELL_ROW_63_800 VGND VPWR sky130_fd_sc_hd__tapvpwrvgnd_1
XTAP_TAPCELL_ROW_35_535 VGND VPWR sky130_fd_sc_hd__tapvpwrvgnd_1
X_3805_ clknet_leaf_18_clk _0623_ net123 VGND VGND VPWR VPWR rx_fifo_in_data\[6\]
+ sky130_fd_sc_hd__dfrtp_1
X_1997_ net193 net23 _0952_ VGND VGND VPWR VPWR _0111_ sky130_fd_sc_hd__mux2_1
X_3736_ clknet_leaf_60_clk _0560_ net89 VGND VGND VPWR VPWR u_uart_tx.bit_index\[2\]
+ sky130_fd_sc_hd__dfrtp_1
Xclkload60 clknet_leaf_28_clk VGND VGND VPWR VPWR clkload60/Y sky130_fd_sc_hd__clkinvlp_4
X_3667_ clknet_leaf_62_clk _0494_ VGND VGND VPWR VPWR u_tx_fifo.mem\[9\]\[1\] sky130_fd_sc_hd__dfxtp_1
X_3598_ clknet_leaf_7_clk _0425_ net96 VGND VGND VPWR VPWR u_parser.u_decoder.ascii_buf\[8\]\[1\]
+ sky130_fd_sc_hd__dfrtp_1
X_2618_ u_parser.u_decoder.ascii_buf\[1\]\[7\] u_parser.u_decoder.ascii_buf\[1\]\[6\]
+ u_parser.u_decoder.ascii_buf\[1\]\[4\] u_parser.u_decoder.ascii_buf\[1\]\[5\] VGND
+ VGND VPWR VPWR _1309_ sky130_fd_sc_hd__and4bb_1
X_2549_ u_parser.u_decoder.ascii_buf\[5\]\[0\] u_parser.u_decoder.ascii_buf\[5\]\[1\]
+ u_parser.u_decoder.ascii_buf\[5\]\[3\] u_parser.u_decoder.ascii_buf\[5\]\[2\] _1255_
+ VGND VGND VPWR VPWR _1256_ sky130_fd_sc_hd__o41a_1
XFILLER_87_234 VGND VGND VPWR VPWR sky130_fd_sc_hd__decap_6
XFILLER_87_223 VGND VGND VPWR VPWR sky130_fd_sc_hd__fill_1
XFILLER_87_278 VGND VGND VPWR VPWR sky130_fd_sc_hd__fill_2
XTAP_TAPCELL_ROW_87_1032 VGND VPWR sky130_fd_sc_hd__tapvpwrvgnd_1
XFILLER_18_45 VGND VGND VPWR VPWR sky130_fd_sc_hd__fill_2
XFILLER_16_529 VGND VGND VPWR VPWR sky130_fd_sc_hd__decap_3
XFILLER_70_101 VPWR VGND VPWR VGND sky130_ef_sc_hd__decap_12
XFILLER_43_337 VGND VGND VPWR VPWR sky130_fd_sc_hd__fill_1
XFILLER_11_223 VGND VGND VPWR VPWR sky130_fd_sc_hd__fill_1
XFILLER_50_65 VPWR VGND VPWR VGND sky130_ef_sc_hd__decap_12
XFILLER_59_63 VGND VGND VPWR VPWR sky130_fd_sc_hd__fill_1
XTAP_TAPCELL_ROW_6_260 VGND VPWR sky130_fd_sc_hd__tapvpwrvgnd_1
XFILLER_93_237 VPWR VGND VPWR VGND sky130_ef_sc_hd__decap_12
XTAP_TAPCELL_ROW_77_936 VGND VPWR sky130_fd_sc_hd__tapvpwrvgnd_1
XFILLER_59_481 VGND VGND VPWR VPWR sky130_fd_sc_hd__decap_4
XFILLER_19_334 VGND VGND VPWR VPWR sky130_fd_sc_hd__fill_2
XFILLER_75_51 VGND VGND VPWR VPWR sky130_fd_sc_hd__decap_4
XFILLER_34_348 VGND VGND VPWR VPWR sky130_fd_sc_hd__fill_1
XFILLER_61_134 VGND VGND VPWR VPWR sky130_fd_sc_hd__fill_1
XTAP_TAPCELL_ROW_32_505 VGND VPWR sky130_fd_sc_hd__tapvpwrvgnd_1
XFILLER_61_167 VGND VGND VPWR VPWR sky130_fd_sc_hd__fill_1
X_1920_ net201 net85 _0941_ VGND VGND VPWR VPWR _0045_ sky130_fd_sc_hd__mux2_1
X_1851_ net210 net84 _0888_ VGND VGND VPWR VPWR _0029_ sky130_fd_sc_hd__mux2_1
X_1782_ u_uart_rx.low_count\[20\] u_uart_rx.low_count\[19\] u_uart_rx.low_count\[18\]
+ u_uart_rx.low_count\[17\] VGND VGND VPWR VPWR _0842_ sky130_fd_sc_hd__or4_1
X_3521_ clknet_leaf_59_clk _0348_ net90 VGND VGND VPWR VPWR u_parser.u_decoder.decoded_payload\[4\]
+ sky130_fd_sc_hd__dfrtp_1
XTAP_TAPCELL_ROW_40_582 VGND VPWR sky130_fd_sc_hd__tapvpwrvgnd_1
X_3452_ clknet_leaf_57_clk _0279_ net95 VGND VGND VPWR VPWR tag_raw\[6\] sky130_fd_sc_hd__dfrtp_1
X_3383_ clknet_leaf_48_clk _0216_ net102 VGND VGND VPWR VPWR u_parser.u_packet_encoder.tag_latched\[19\]
+ sky130_fd_sc_hd__dfrtp_1
X_2403_ _0813_ _0964_ _1147_ _1146_ u_parser.u_decoder.index\[1\] VGND VGND VPWR VPWR
+ _0322_ sky130_fd_sc_hd__a32o_1
X_2334_ net78 net371 _1132_ VGND VGND VPWR VPWR _0268_ sky130_fd_sc_hd__mux2_1
XFILLER_69_256 VGND VGND VPWR VPWR sky130_fd_sc_hd__decap_8
X_2265_ _0682_ _1070_ _1073_ _1074_ VGND VGND VPWR VPWR _1075_ sky130_fd_sc_hd__a22o_1
X_2196_ tag_raw\[3\] net550 net55 VGND VGND VPWR VPWR _0200_ sky130_fd_sc_hd__mux2_1
XTAP_TAPCELL_ROW_48_660 VGND VPWR sky130_fd_sc_hd__tapvpwrvgnd_1
XFILLER_52_101 VGND VGND VPWR VPWR sky130_fd_sc_hd__fill_1
XFILLER_92_281 VPWR VGND VPWR VGND sky130_ef_sc_hd__decap_12
XFILLER_80_421 VGND VGND VPWR VPWR sky130_fd_sc_hd__decap_6
XFILLER_52_134 VGND VGND VPWR VPWR sky130_fd_sc_hd__decap_6
XFILLER_80_465 VGND VGND VPWR VPWR sky130_fd_sc_hd__decap_3
XFILLER_80_454 VGND VGND VPWR VPWR sky130_fd_sc_hd__decap_3
XFILLER_40_329 VPWR VGND VPWR VGND sky130_ef_sc_hd__decap_12
XFILLER_21_554 VGND VGND VPWR VPWR sky130_fd_sc_hd__fill_1
X_3719_ clknet_leaf_33_clk _0543_ net140 VGND VGND VPWR VPWR u_uart_rx.low_count\[9\]
+ sky130_fd_sc_hd__dfrtp_1
XFILLER_88_510 VPWR VGND VPWR VGND sky130_ef_sc_hd__decap_12
XTAP_TAPCELL_ROW_93_1091 VGND VPWR sky130_fd_sc_hd__tapvpwrvgnd_1
Xhold11 u_tx_fifo.mem\[0\]\[7\] VGND VGND VPWR VPWR net167 sky130_fd_sc_hd__dlygate4sd3_1
Xhold22 u_tx_fifo.mem\[0\]\[1\] VGND VGND VPWR VPWR net178 sky130_fd_sc_hd__dlygate4sd3_1
Xhold44 u_rx_fifo.mem\[2\]\[3\] VGND VGND VPWR VPWR net200 sky130_fd_sc_hd__dlygate4sd3_1
Xhold55 u_tx_fifo.mem\[12\]\[6\] VGND VGND VPWR VPWR net211 sky130_fd_sc_hd__dlygate4sd3_1
Xhold33 u_tx_fifo.mem\[0\]\[3\] VGND VGND VPWR VPWR net189 sky130_fd_sc_hd__dlygate4sd3_1
XTAP_TAPCELL_ROW_3_230 VGND VPWR sky130_fd_sc_hd__tapvpwrvgnd_1
Xhold88 u_tx_fifo.mem\[2\]\[3\] VGND VGND VPWR VPWR net244 sky130_fd_sc_hd__dlygate4sd3_1
Xhold99 u_rx_fifo.mem\[13\]\[4\] VGND VGND VPWR VPWR net255 sky130_fd_sc_hd__dlygate4sd3_1
Xhold66 u_rx_fifo.mem\[14\]\[2\] VGND VGND VPWR VPWR net222 sky130_fd_sc_hd__dlygate4sd3_1
Xhold77 u_rx_fifo.mem\[10\]\[0\] VGND VGND VPWR VPWR net233 sky130_fd_sc_hd__dlygate4sd3_1
XTAP_TAPCELL_ROW_74_906 VGND VPWR sky130_fd_sc_hd__tapvpwrvgnd_1
XFILLER_75_248 VGND VGND VPWR VPWR sky130_fd_sc_hd__decap_8
XFILLER_16_337 VGND VGND VPWR VPWR sky130_fd_sc_hd__fill_1
XTAP_TAPCELL_ROW_82_983 VGND VPWR sky130_fd_sc_hd__tapvpwrvgnd_1
XFILLER_31_329 VGND VGND VPWR VPWR sky130_fd_sc_hd__decap_6
XFILLER_8_525 VGND VGND VPWR VPWR sky130_fd_sc_hd__decap_6
XFILLER_6_15 VPWR VGND VPWR VGND sky130_ef_sc_hd__decap_12
XFILLER_79_521 VGND VGND VPWR VPWR sky130_fd_sc_hd__fill_1
XFILLER_47_440 VGND VGND VPWR VPWR sky130_fd_sc_hd__decap_8
X_2050_ net184 net85 _0959_ VGND VGND VPWR VPWR _0157_ sky130_fd_sc_hd__mux2_1
XTAP_TAPCELL_ROW_45_630 VGND VPWR sky130_fd_sc_hd__tapvpwrvgnd_1
XFILLER_62_421 VGND VGND VPWR VPWR sky130_fd_sc_hd__decap_4
XFILLER_62_432 VGND VGND VPWR VPWR sky130_fd_sc_hd__decap_8
XFILLER_22_307 VGND VGND VPWR VPWR sky130_fd_sc_hd__fill_1
X_2952_ u_uart_rx.low_count\[5\] _1476_ u_uart_rx.low_count\[6\] VGND VGND VPWR VPWR
+ _1479_ sky130_fd_sc_hd__a21oi_1
XTAP_TAPCELL_ROW_17_365 VGND VPWR sky130_fd_sc_hd__tapvpwrvgnd_1
X_1903_ u_parser.u_packet_encoder.tag_latched\[13\] _0894_ VGND VGND VPWR VPWR _0928_
+ sky130_fd_sc_hd__and2_1
X_2883_ net24 net383 _1438_ VGND VGND VPWR VPWR _0511_ sky130_fd_sc_hd__mux2_1
X_1834_ parser_tx_valid _0880_ VGND VGND VPWR VPWR _0881_ sky130_fd_sc_hd__and2_2
X_1765_ _0825_ _0827_ VGND VGND VPWR VPWR _0828_ sky130_fd_sc_hd__or2_1
X_3504_ clknet_leaf_28_clk _0331_ net137 VGND VGND VPWR VPWR u_parser.u_decoder.timeout_count\[6\]
+ sky130_fd_sc_hd__dfrtp_1
XFILLER_89_329 VGND VGND VPWR VPWR sky130_fd_sc_hd__decap_6
X_3435_ clknet_leaf_14_clk _0268_ VGND VGND VPWR VPWR u_rx_fifo.mem\[1\]\[3\] sky130_fd_sc_hd__dfxtp_1
X_1696_ net145 _0762_ VGND VGND VPWR VPWR _0763_ sky130_fd_sc_hd__or2_1
X_3366_ clknet_leaf_48_clk _0199_ net103 VGND VGND VPWR VPWR u_parser.u_packet_encoder.tag_latched\[2\]
+ sky130_fd_sc_hd__dfrtp_1
X_3297_ clknet_leaf_63_clk _0133_ VGND VGND VPWR VPWR u_tx_fifo.mem\[14\]\[0\] sky130_fd_sc_hd__dfxtp_1
X_2317_ _0681_ _1120_ VGND VGND VPWR VPWR _1121_ sky130_fd_sc_hd__or2_1
X_2248_ net195 net19 _1067_ VGND VGND VPWR VPWR _0247_ sky130_fd_sc_hd__mux2_1
XTAP_TAPCELL_ROW_0_200 VGND VPWR sky130_fd_sc_hd__tapvpwrvgnd_1
XTAP_TAPCELL_ROW_84_1002 VGND VPWR sky130_fd_sc_hd__tapvpwrvgnd_1
X_2179_ _1048_ _1051_ VGND VGND VPWR VPWR _1053_ sky130_fd_sc_hd__xnor2_1
XFILLER_53_410 VPWR VGND VPWR VGND sky130_ef_sc_hd__decap_12
XFILLER_65_281 VGND VGND VPWR VPWR sky130_fd_sc_hd__fill_1
XFILLER_53_465 VPWR VGND VPWR VGND sky130_ef_sc_hd__decap_12
XFILLER_15_24 VGND VGND VPWR VPWR sky130_fd_sc_hd__fill_1
XFILLER_40_104 VGND VGND VPWR VPWR sky130_fd_sc_hd__decap_4
XTAP_TAPCELL_ROW_51_688 VGND VPWR sky130_fd_sc_hd__tapvpwrvgnd_1
XFILLER_5_517 VPWR VGND VPWR VGND sky130_ef_sc_hd__decap_12
XFILLER_0_277 VGND VGND VPWR VPWR sky130_fd_sc_hd__decap_3
XFILLER_91_505 VPWR VGND VPWR VGND sky130_ef_sc_hd__decap_12
XTAP_TAPCELL_ROW_59_766 VGND VPWR sky130_fd_sc_hd__tapvpwrvgnd_1
XFILLER_16_123 VGND VGND VPWR VPWR sky130_fd_sc_hd__fill_1
XTAP_TAPCELL_ROW_42_600 VGND VPWR sky130_fd_sc_hd__tapvpwrvgnd_1
XTAP_TAPCELL_ROW_14_335 VGND VPWR sky130_fd_sc_hd__tapvpwrvgnd_1
XFILLER_72_85 VGND VGND VPWR VPWR sky130_fd_sc_hd__decap_8
XFILLER_12_373 VGND VGND VPWR VPWR sky130_fd_sc_hd__decap_3
XFILLER_8_377 VPWR VGND VPWR VGND sky130_ef_sc_hd__decap_12
X_3220_ clknet_leaf_14_clk _0056_ VGND VGND VPWR VPWR u_rx_fifo.mem\[7\]\[3\] sky130_fd_sc_hd__dfxtp_1
X_3151_ _0705_ _1572_ VGND VGND VPWR VPWR _1582_ sky130_fd_sc_hd__nor2_1
X_2102_ tag_raw\[34\] tag_raw\[26\] VGND VGND VPWR VPWR _0980_ sky130_fd_sc_hd__xnor2_2
XFILLER_67_546 VGND VGND VPWR VPWR sky130_fd_sc_hd__decap_8
X_3082_ _1540_ _1541_ VGND VGND VPWR VPWR _0607_ sky130_fd_sc_hd__nor2_1
X_2033_ net25 net263 _0957_ VGND VGND VPWR VPWR _0142_ sky130_fd_sc_hd__mux2_1
XFILLER_35_443 VGND VGND VPWR VPWR sky130_fd_sc_hd__decap_4
X_2935_ u_uart_tx.bit_index\[2\] _1468_ _1467_ _0827_ VGND VGND VPWR VPWR _1469_ sky130_fd_sc_hd__a211o_1
X_2866_ net34 net299 _1436_ VGND VGND VPWR VPWR _0496_ sky130_fd_sc_hd__mux2_1
X_1817_ _0866_ _0867_ VGND VGND VPWR VPWR _0016_ sky130_fd_sc_hd__and2_1
Xhold311 u_parser.u_packet_encoder.tag_latched\[15\] VGND VGND VPWR VPWR net467 sky130_fd_sc_hd__dlygate4sd3_1
X_2797_ net534 _0744_ _1409_ VGND VGND VPWR VPWR _0454_ sky130_fd_sc_hd__mux2_1
Xhold300 u_parser.u_decoder.decoded_payload\[15\] VGND VGND VPWR VPWR net456 sky130_fd_sc_hd__dlygate4sd3_1
Xhold333 u_parser.u_decoder.decoded_payload\[6\] VGND VGND VPWR VPWR net489 sky130_fd_sc_hd__dlygate4sd3_1
Xhold322 _0209_ VGND VGND VPWR VPWR net478 sky130_fd_sc_hd__dlygate4sd3_1
Xhold344 u_parser.u_decoder.decoded_payload\[28\] VGND VGND VPWR VPWR net500 sky130_fd_sc_hd__dlygate4sd3_1
X_1748_ u_parser.u_decoder.index\[0\] u_parser.u_decoder.index\[1\] VGND VGND VPWR
+ VPWR _0813_ sky130_fd_sc_hd__or2_2
Xhold377 u_parser.u_packet_encoder.tag_latched\[4\] VGND VGND VPWR VPWR net533 sky130_fd_sc_hd__dlygate4sd3_1
Xhold366 u_parser.u_packet_encoder.tag_latched\[20\] VGND VGND VPWR VPWR net522 sky130_fd_sc_hd__dlygate4sd3_1
Xhold355 u_parser.u_packet_encoder.tag_latched\[9\] VGND VGND VPWR VPWR net511 sky130_fd_sc_hd__dlygate4sd3_1
X_1679_ net145 _0745_ VGND VGND VPWR VPWR _0746_ sky130_fd_sc_hd__or2_1
Xhold388 u_uart_rx.state\[4\] VGND VGND VPWR VPWR net544 sky130_fd_sc_hd__dlygate4sd3_1
X_3418_ clknet_leaf_10_clk _0251_ VGND VGND VPWR VPWR u_rx_fifo.mem\[15\]\[2\] sky130_fd_sc_hd__dfxtp_1
Xhold399 u_rx_fifo.level\[3\] VGND VGND VPWR VPWR net555 sky130_fd_sc_hd__dlygate4sd3_1
XTAP_TAPCELL_ROW_90_1061 VGND VPWR sky130_fd_sc_hd__tapvpwrvgnd_1
X_3349_ clknet_leaf_37_clk _0182_ net129 VGND VGND VPWR VPWR u_parser.u_decoder.ascii_buf\[11\]\[1\]
+ sky130_fd_sc_hd__dfrtp_2
XFILLER_93_29 VPWR VGND VPWR VGND sky130_ef_sc_hd__decap_12
XFILLER_85_365 VGND VGND VPWR VPWR sky130_fd_sc_hd__fill_1
XFILLER_26_410 VGND VGND VPWR VPWR sky130_fd_sc_hd__decap_3
XFILLER_38_281 VGND VGND VPWR VPWR sky130_fd_sc_hd__decap_8
XTAP_TAPCELL_ROW_56_736 VGND VPWR sky130_fd_sc_hd__tapvpwrvgnd_1
XTAP_TAPCELL_ROW_11_305 VGND VPWR sky130_fd_sc_hd__tapvpwrvgnd_1
XFILLER_42_77 VGND VGND VPWR VPWR sky130_fd_sc_hd__decap_6
XFILLER_1_553 VGND VGND VPWR VPWR sky130_fd_sc_hd__fill_2
XFILLER_3_27 VGND VGND VPWR VPWR sky130_fd_sc_hd__decap_4
XFILLER_88_170 VGND VGND VPWR VPWR sky130_fd_sc_hd__decap_6
XFILLER_91_335 VGND VGND VPWR VPWR sky130_fd_sc_hd__fill_1
XFILLER_76_387 VGND VGND VPWR VPWR sky130_fd_sc_hd__decap_8
XFILLER_17_421 VGND VGND VPWR VPWR sky130_fd_sc_hd__fill_1
XFILLER_29_281 VGND VGND VPWR VPWR sky130_fd_sc_hd__fill_1
XFILLER_36_229 VGND VGND VPWR VPWR sky130_fd_sc_hd__decap_4
XFILLER_64_527 VGND VGND VPWR VPWR sky130_fd_sc_hd__decap_4
XFILLER_83_51 VGND VGND VPWR VPWR sky130_fd_sc_hd__decap_4
XTAP_TAPCELL_ROW_27_460 VGND VPWR sky130_fd_sc_hd__tapvpwrvgnd_1
XFILLER_44_251 VGND VGND VPWR VPWR sky130_fd_sc_hd__fill_1
XFILLER_44_273 VGND VGND VPWR VPWR sky130_fd_sc_hd__decap_6
XPHY_EDGE_ROW_17_Left_111 VGND VGND VPWR VPWR sky130_fd_sc_hd__decap_3
XFILLER_44_295 VGND VGND VPWR VPWR sky130_fd_sc_hd__fill_2
X_2720_ net584 net43 _1374_ VGND VGND VPWR VPWR _0412_ sky130_fd_sc_hd__mux2_1
XFILLER_12_192 VGND VGND VPWR VPWR sky130_fd_sc_hd__decap_4
X_2651_ u_parser.u_decoder.ascii_buf\[0\]\[0\] u_parser.u_decoder.ascii_buf\[0\]\[1\]
+ _1327_ u_parser.u_decoder.ascii_buf\[0\]\[2\] VGND VGND VPWR VPWR _1336_ sky130_fd_sc_hd__a31o_1
X_1602_ u_parser.u_decoder.timeout_count\[13\] VGND VGND VPWR VPWR _0672_ sky130_fd_sc_hd__inv_2
X_2582_ u_parser.u_decoder.ascii_buf\[3\]\[7\] u_parser.u_decoder.ascii_buf\[3\]\[6\]
+ VGND VGND VPWR VPWR _1281_ sky130_fd_sc_hd__nor2_1
XFILLER_59_3 VPWR VGND VPWR VGND sky130_ef_sc_hd__decap_12
XPHY_EDGE_ROW_26_Left_120 VGND VGND VPWR VPWR sky130_fd_sc_hd__decap_3
Xfanout109 net112 VGND VGND VPWR VPWR net109 sky130_fd_sc_hd__clkbuf_4
X_3203_ clknet_leaf_3_clk _0039_ VGND VGND VPWR VPWR u_tx_fifo.mem\[7\]\[2\] sky130_fd_sc_hd__dfxtp_1
X_3134_ net59 _1568_ _1570_ VGND VGND VPWR VPWR _0630_ sky130_fd_sc_hd__o21a_1
XFILLER_55_505 VGND VGND VPWR VPWR sky130_fd_sc_hd__decap_4
X_3065_ _1522_ _1529_ VGND VGND VPWR VPWR _1530_ sky130_fd_sc_hd__and2_1
XFILLER_82_313 VGND VGND VPWR VPWR sky130_fd_sc_hd__fill_1
X_2016_ net24 net351 _0955_ VGND VGND VPWR VPWR _0127_ sky130_fd_sc_hd__mux2_1
XTAP_TAPCELL_ROW_53_706 VGND VPWR sky130_fd_sc_hd__tapvpwrvgnd_1
X_2918_ u_uart_tx.clk_count\[9\] _1456_ _1441_ VGND VGND VPWR VPWR _1459_ sky130_fd_sc_hd__o21ai_1
XFILLER_50_287 VPWR VGND VPWR VGND sky130_ef_sc_hd__decap_12
XTAP_TAPCELL_ROW_61_783 VGND VPWR sky130_fd_sc_hd__tapvpwrvgnd_1
Xclkbuf_leaf_30_clk clknet_3_7__leaf_clk VGND VGND VPWR VPWR clknet_leaf_30_clk sky130_fd_sc_hd__clkbuf_8
X_2849_ u_tx_fifo.wr_ptr\[2\] _0889_ VGND VGND VPWR VPWR _1429_ sky130_fd_sc_hd__or2_1
Xhold141 u_rx_fifo.mem\[3\]\[4\] VGND VGND VPWR VPWR net297 sky130_fd_sc_hd__dlygate4sd3_1
XFILLER_88_29 VPWR VGND VPWR VGND sky130_ef_sc_hd__decap_12
Xhold152 u_tx_fifo.mem\[5\]\[5\] VGND VGND VPWR VPWR net308 sky130_fd_sc_hd__dlygate4sd3_1
Xhold130 u_rx_fifo.mem\[14\]\[0\] VGND VGND VPWR VPWR net286 sky130_fd_sc_hd__dlygate4sd3_1
Xhold174 u_tx_fifo.mem\[13\]\[5\] VGND VGND VPWR VPWR net330 sky130_fd_sc_hd__dlygate4sd3_1
Xhold185 u_tx_fifo.mem\[11\]\[0\] VGND VGND VPWR VPWR net341 sky130_fd_sc_hd__dlygate4sd3_1
Xhold163 u_rx_fifo.mem\[11\]\[3\] VGND VGND VPWR VPWR net319 sky130_fd_sc_hd__dlygate4sd3_1
Xhold196 u_rx_fifo.mem\[11\]\[1\] VGND VGND VPWR VPWR net352 sky130_fd_sc_hd__dlygate4sd3_1
XTAP_TAPCELL_ROW_69_861 VGND VPWR sky130_fd_sc_hd__tapvpwrvgnd_1
XFILLER_73_335 VGND VGND VPWR VPWR sky130_fd_sc_hd__fill_1
XFILLER_73_324 VGND VGND VPWR VPWR sky130_fd_sc_hd__fill_2
XTAP_TAPCELL_ROW_24_430 VGND VPWR sky130_fd_sc_hd__tapvpwrvgnd_1
XFILLER_41_254 VPWR VGND VPWR VGND sky130_ef_sc_hd__decap_12
Xclkbuf_leaf_21_clk clknet_3_4__leaf_clk VGND VGND VPWR VPWR clknet_leaf_21_clk sky130_fd_sc_hd__clkbuf_8
XFILLER_5_100 VGND VGND VPWR VPWR sky130_fd_sc_hd__fill_1
XFILLER_1_372 VPWR VGND VPWR VGND sky130_ef_sc_hd__decap_12
XFILLER_49_332 VGND VGND VPWR VPWR sky130_fd_sc_hd__decap_4
XFILLER_64_302 VGND VGND VPWR VPWR sky130_fd_sc_hd__decap_6
XFILLER_17_295 VGND VGND VPWR VPWR sky130_fd_sc_hd__fill_1
X_3821_ clknet_leaf_18_clk _0637_ net123 VGND VGND VPWR VPWR u_uart_rx.rx_shift\[6\]
+ sky130_fd_sc_hd__dfrtp_1
XFILLER_20_449 VGND VGND VPWR VPWR sky130_fd_sc_hd__fill_1
XFILLER_9_461 VPWR VGND VPWR VGND sky130_ef_sc_hd__decap_12
X_3752_ clknet_leaf_0_clk _0570_ VGND VGND VPWR VPWR u_tx_fifo.mem\[15\]\[1\] sky130_fd_sc_hd__dfxtp_1
Xclkbuf_leaf_12_clk clknet_3_4__leaf_clk VGND VGND VPWR VPWR clknet_leaf_12_clk sky130_fd_sc_hd__clkbuf_8
XTAP_TAPCELL_ROW_30_488 VGND VPWR sky130_fd_sc_hd__tapvpwrvgnd_1
X_3683_ clknet_leaf_6_clk _0510_ VGND VGND VPWR VPWR u_tx_fifo.mem\[1\]\[1\] sky130_fd_sc_hd__dfxtp_1
X_2703_ net579 net35 _1372_ VGND VGND VPWR VPWR _0397_ sky130_fd_sc_hd__mux2_1
X_2634_ net496 _1322_ net11 VGND VGND VPWR VPWR _0378_ sky130_fd_sc_hd__mux2_1
X_2565_ u_parser.u_decoder.ascii_buf\[4\]\[3\] _1265_ _1266_ u_parser.u_decoder.ascii_buf\[4\]\[7\]
+ u_parser.u_decoder.ascii_buf\[4\]\[6\] VGND VGND VPWR VPWR _1268_ sky130_fd_sc_hd__a2111o_1
XFILLER_4_70 VGND VGND VPWR VPWR sky130_fd_sc_hd__decap_4
X_2496_ u_parser.u_decoder.ascii_buf\[8\]\[0\] _1214_ _1211_ VGND VGND VPWR VPWR _1215_
+ sky130_fd_sc_hd__o21a_1
XFILLER_87_449 VGND VGND VPWR VPWR sky130_fd_sc_hd__decap_6
XFILLER_82_110 VGND VGND VPWR VPWR sky130_fd_sc_hd__fill_1
X_3117_ net66 net49 VGND VGND VPWR VPWR _1559_ sky130_fd_sc_hd__nand2_1
XFILLER_28_527 VGND VGND VPWR VPWR sky130_fd_sc_hd__decap_4
XTAP_TAPCELL_ROW_66_831 VGND VPWR sky130_fd_sc_hd__tapvpwrvgnd_1
XFILLER_55_346 VPWR VGND VPWR VGND sky130_ef_sc_hd__decap_12
X_3048_ _0688_ _1510_ VGND VGND VPWR VPWR _1519_ sky130_fd_sc_hd__and2_1
XFILLER_82_176 VGND VGND VPWR VPWR sky130_fd_sc_hd__decap_4
XTAP_TAPCELL_ROW_38_566 VGND VPWR sky130_fd_sc_hd__tapvpwrvgnd_1
XTAP_TAPCELL_ROW_21_400 VGND VPWR sky130_fd_sc_hd__tapvpwrvgnd_1
XFILLER_11_449 VPWR VGND VPWR VGND sky130_ef_sc_hd__decap_12
XFILLER_2_136 VGND VGND VPWR VPWR sky130_fd_sc_hd__decap_4
XFILLER_48_65 VPWR VGND VPWR VGND sky130_ef_sc_hd__decap_12
XFILLER_19_549 VGND VGND VPWR VPWR sky130_fd_sc_hd__decap_6
XFILLER_34_508 VGND VGND VPWR VPWR sky130_fd_sc_hd__fill_1
XFILLER_64_53 VPWR VGND VPWR VGND sky130_ef_sc_hd__decap_12
XFILLER_42_530 VGND VGND VPWR VPWR sky130_fd_sc_hd__fill_2
XFILLER_9_15 VPWR VGND VPWR VGND sky130_ef_sc_hd__decap_12
XTAP_TAPCELL_ROW_72_889 VGND VPWR sky130_fd_sc_hd__tapvpwrvgnd_1
Xfanout80 net81 VGND VGND VPWR VPWR net80 sky130_fd_sc_hd__clkbuf_2
Xfanout91 net94 VGND VGND VPWR VPWR net91 sky130_fd_sc_hd__clkbuf_4
XFILLER_6_475 VGND VGND VPWR VPWR sky130_fd_sc_hd__fill_1
X_2350_ tag_raw\[3\] net468 net17 VGND VGND VPWR VPWR _0276_ sky130_fd_sc_hd__mux2_1
XFILLER_69_405 VPWR VGND VPWR VGND sky130_ef_sc_hd__decap_12
X_2281_ _0681_ _1088_ VGND VGND VPWR VPWR _1089_ sky130_fd_sc_hd__or2_1
XTAP_TAPCELL_ROW_9_291 VGND VPWR sky130_fd_sc_hd__tapvpwrvgnd_1
Xclkbuf_leaf_1_clk clknet_3_1__leaf_clk VGND VGND VPWR VPWR clknet_leaf_1_clk sky130_fd_sc_hd__clkbuf_8
XFILLER_77_493 VGND VGND VPWR VPWR sky130_fd_sc_hd__decap_6
XFILLER_37_302 VGND VGND VPWR VPWR sky130_fd_sc_hd__decap_4
XTAP_TAPCELL_ROW_63_801 VGND VPWR sky130_fd_sc_hd__tapvpwrvgnd_1
XTAP_TAPCELL_ROW_35_536 VGND VPWR sky130_fd_sc_hd__tapvpwrvgnd_1
XFILLER_64_187 VGND VGND VPWR VPWR sky130_fd_sc_hd__fill_1
X_3804_ clknet_leaf_18_clk _0622_ net121 VGND VGND VPWR VPWR rx_fifo_in_data\[5\]
+ sky130_fd_sc_hd__dfrtp_1
X_1996_ net234 net25 _0952_ VGND VGND VPWR VPWR _0110_ sky130_fd_sc_hd__mux2_1
X_3735_ clknet_leaf_60_clk _0559_ net89 VGND VGND VPWR VPWR u_uart_tx.bit_index\[1\]
+ sky130_fd_sc_hd__dfrtp_1
Xclkload61 clknet_leaf_29_clk VGND VGND VPWR VPWR clkload61/Y sky130_fd_sc_hd__clkinv_8
X_3666_ clknet_leaf_63_clk _0493_ VGND VGND VPWR VPWR u_tx_fifo.mem\[9\]\[0\] sky130_fd_sc_hd__dfxtp_1
Xclkload50 clknet_leaf_20_clk VGND VGND VPWR VPWR clkload50/Y sky130_fd_sc_hd__inv_12
X_2617_ u_parser.u_decoder.ascii_buf\[1\]\[1\] u_parser.u_decoder.ascii_buf\[1\]\[2\]
+ u_parser.u_decoder.ascii_buf\[1\]\[3\] VGND VGND VPWR VPWR _1308_ sky130_fd_sc_hd__o21ai_1
X_3597_ clknet_leaf_7_clk _0424_ net96 VGND VGND VPWR VPWR u_parser.u_decoder.ascii_buf\[8\]\[0\]
+ sky130_fd_sc_hd__dfrtp_1
X_2548_ u_parser.u_decoder.ascii_buf\[5\]\[0\] u_parser.u_decoder.ascii_buf\[5\]\[1\]
+ u_parser.u_decoder.ascii_buf\[5\]\[2\] _1254_ VGND VGND VPWR VPWR _1255_ sky130_fd_sc_hd__a31oi_1
X_2479_ u_parser.u_decoder.ascii_buf\[9\]\[5\] _1198_ _1199_ net48 VGND VGND VPWR
+ VPWR _1201_ sky130_fd_sc_hd__a211o_1
XFILLER_70_113 VPWR VGND VPWR VGND sky130_ef_sc_hd__decap_12
XFILLER_34_45 VGND VGND VPWR VPWR sky130_fd_sc_hd__fill_1
XFILLER_34_78 VGND VGND VPWR VPWR sky130_fd_sc_hd__decap_6
XFILLER_11_279 VGND VGND VPWR VPWR sky130_fd_sc_hd__fill_1
Xclkload0 clknet_3_1__leaf_clk VGND VGND VPWR VPWR clkload0/X sky130_fd_sc_hd__clkbuf_8
XFILLER_50_77 VGND VGND VPWR VPWR sky130_fd_sc_hd__decap_6
XFILLER_78_213 VGND VGND VPWR VPWR sky130_fd_sc_hd__decap_4
XTAP_TAPCELL_ROW_6_261 VGND VPWR sky130_fd_sc_hd__tapvpwrvgnd_1
XTAP_TAPCELL_ROW_77_937 VGND VPWR sky130_fd_sc_hd__tapvpwrvgnd_1
XFILLER_93_249 VGND VGND VPWR VPWR sky130_fd_sc_hd__decap_3
XFILLER_19_346 VGND VGND VPWR VPWR sky130_fd_sc_hd__decap_6
XFILLER_19_357 VGND VGND VPWR VPWR sky130_fd_sc_hd__fill_1
XFILLER_46_121 VPWR VGND VPWR VGND sky130_ef_sc_hd__decap_12
XFILLER_91_51 VGND VGND VPWR VPWR sky130_fd_sc_hd__decap_4
XTAP_TAPCELL_ROW_32_506 VGND VPWR sky130_fd_sc_hd__tapvpwrvgnd_1
XFILLER_42_382 VGND VGND VPWR VPWR sky130_fd_sc_hd__fill_1
XFILLER_30_533 VPWR VGND VPWR VGND sky130_ef_sc_hd__decap_12
X_1850_ _0886_ _0887_ VGND VGND VPWR VPWR _0888_ sky130_fd_sc_hd__nor2_4
X_1781_ u_uart_rx.low_count\[14\] _0840_ u_uart_rx.low_count\[16\] u_uart_rx.low_count\[15\]
+ VGND VGND VPWR VPWR _0841_ sky130_fd_sc_hd__o211a_1
X_3520_ clknet_leaf_46_clk _0347_ net104 VGND VGND VPWR VPWR u_parser.u_decoder.decoded_payload\[3\]
+ sky130_fd_sc_hd__dfrtp_1
XTAP_TAPCELL_ROW_40_583 VGND VPWR sky130_fd_sc_hd__tapvpwrvgnd_1
XFILLER_10_290 VPWR VGND VPWR VGND sky130_ef_sc_hd__decap_12
X_3451_ clknet_leaf_59_clk _0278_ net93 VGND VGND VPWR VPWR tag_raw\[5\] sky130_fd_sc_hd__dfrtp_1
X_3382_ clknet_leaf_46_clk net519 net104 VGND VGND VPWR VPWR u_parser.u_packet_encoder.tag_latched\[18\]
+ sky130_fd_sc_hd__dfrtp_1
XFILLER_41_3 VPWR VGND VPWR VGND sky130_ef_sc_hd__decap_12
X_2402_ _1147_ _1146_ u_parser.u_decoder.index\[0\] VGND VGND VPWR VPWR _0321_ sky130_fd_sc_hd__mux2_1
X_2333_ net80 net410 _1132_ VGND VGND VPWR VPWR _0267_ sky130_fd_sc_hd__mux2_1
XFILLER_69_213 VGND VGND VPWR VPWR sky130_fd_sc_hd__decap_8
X_2264_ net60 _1071_ u_tx_fifo.rd_ptr\[3\] VGND VGND VPWR VPWR _1074_ sky130_fd_sc_hd__o21a_1
XFILLER_69_279 VGND VGND VPWR VPWR sky130_fd_sc_hd__fill_1
X_2195_ tag_raw\[2\] net538 net55 VGND VGND VPWR VPWR _0199_ sky130_fd_sc_hd__mux2_1
XPHY_EDGE_ROW_9_Left_103 VGND VGND VPWR VPWR sky130_fd_sc_hd__decap_3
XTAP_TAPCELL_ROW_48_661 VGND VPWR sky130_fd_sc_hd__tapvpwrvgnd_1
XFILLER_92_293 VPWR VGND VPWR VGND sky130_ef_sc_hd__decap_12
XFILLER_80_477 VGND VGND VPWR VPWR sky130_fd_sc_hd__fill_2
XFILLER_80_444 VGND VGND VPWR VPWR sky130_fd_sc_hd__decap_4
XFILLER_80_499 VGND VGND VPWR VPWR sky130_fd_sc_hd__decap_8
XFILLER_21_522 VPWR VGND VPWR VGND sky130_ef_sc_hd__decap_12
X_1979_ net76 net297 _0948_ VGND VGND VPWR VPWR _0097_ sky130_fd_sc_hd__mux2_1
X_3718_ clknet_leaf_33_clk _0542_ net141 VGND VGND VPWR VPWR u_uart_rx.low_count\[8\]
+ sky130_fd_sc_hd__dfrtp_1
X_3649_ clknet_leaf_8_clk _0476_ net116 VGND VGND VPWR VPWR u_parser.u_decoder.ascii_buf\[4\]\[4\]
+ sky130_fd_sc_hd__dfrtp_1
XTAP_TAPCELL_ROW_93_1092 VGND VPWR sky130_fd_sc_hd__tapvpwrvgnd_1
XTAP_TAPCELL_ROW_93_1081 VGND VPWR sky130_fd_sc_hd__tapvpwrvgnd_1
XFILLER_88_533 VPWR VGND VPWR VGND sky130_ef_sc_hd__decap_12
XFILLER_88_522 VGND VGND VPWR VPWR sky130_fd_sc_hd__decap_8
Xhold12 u_tx_fifo.mem\[8\]\[3\] VGND VGND VPWR VPWR net168 sky130_fd_sc_hd__dlygate4sd3_1
XFILLER_29_23 VGND VGND VPWR VPWR sky130_fd_sc_hd__fill_2
Xhold23 u_rx_fifo.mem\[12\]\[7\] VGND VGND VPWR VPWR net179 sky130_fd_sc_hd__dlygate4sd3_1
Xhold34 u_tx_fifo.mem\[10\]\[0\] VGND VGND VPWR VPWR net190 sky130_fd_sc_hd__dlygate4sd3_1
Xhold56 u_tx_fifo.mem\[13\]\[7\] VGND VGND VPWR VPWR net212 sky130_fd_sc_hd__dlygate4sd3_1
XFILLER_48_419 VGND VGND VPWR VPWR sky130_fd_sc_hd__fill_1
Xhold45 u_rx_fifo.mem\[13\]\[0\] VGND VGND VPWR VPWR net201 sky130_fd_sc_hd__dlygate4sd3_1
XFILLER_75_205 VGND VGND VPWR VPWR sky130_fd_sc_hd__fill_1
XTAP_TAPCELL_ROW_3_231 VGND VPWR sky130_fd_sc_hd__tapvpwrvgnd_1
Xhold78 u_tx_fifo.mem\[12\]\[1\] VGND VGND VPWR VPWR net234 sky130_fd_sc_hd__dlygate4sd3_1
Xhold89 u_tx_fifo.mem\[6\]\[4\] VGND VGND VPWR VPWR net245 sky130_fd_sc_hd__dlygate4sd3_1
XFILLER_29_89 VGND VGND VPWR VPWR sky130_fd_sc_hd__decap_4
Xhold67 u_rx_fifo.mem\[8\]\[1\] VGND VGND VPWR VPWR net223 sky130_fd_sc_hd__dlygate4sd3_1
XTAP_TAPCELL_ROW_74_907 VGND VPWR sky130_fd_sc_hd__tapvpwrvgnd_1
XFILLER_43_113 VGND VGND VPWR VPWR sky130_fd_sc_hd__fill_1
XFILLER_45_55 VGND VGND VPWR VPWR sky130_fd_sc_hd__fill_1
XTAP_TAPCELL_ROW_82_984 VGND VPWR sky130_fd_sc_hd__tapvpwrvgnd_1
XFILLER_12_533 VPWR VGND VPWR VGND sky130_ef_sc_hd__decap_12
XFILLER_6_27 VGND VGND VPWR VPWR sky130_fd_sc_hd__fill_1
XFILLER_81_208 VPWR VGND VPWR VGND sky130_ef_sc_hd__decap_12
XFILLER_34_102 VGND VGND VPWR VPWR sky130_fd_sc_hd__decap_3
XFILLER_47_496 VGND VGND VPWR VPWR sky130_fd_sc_hd__decap_8
XTAP_TAPCELL_ROW_45_631 VGND VPWR sky130_fd_sc_hd__tapvpwrvgnd_1
X_2951_ u_uart_rx.low_count\[5\] _1476_ _1478_ VGND VGND VPWR VPWR _0539_ sky130_fd_sc_hd__o21a_1
XTAP_TAPCELL_ROW_17_366 VGND VPWR sky130_fd_sc_hd__tapvpwrvgnd_1
XFILLER_15_393 VPWR VGND VPWR VGND sky130_ef_sc_hd__decap_12
X_1902_ net32 net338 _0892_ VGND VGND VPWR VPWR _0041_ sky130_fd_sc_hd__mux2_1
XFILLER_30_330 VPWR VGND VPWR VGND sky130_ef_sc_hd__decap_12
XFILLER_89_3 VPWR VGND VPWR VGND sky130_ef_sc_hd__decap_12
X_2882_ net26 net335 _1438_ VGND VGND VPWR VPWR _0510_ sky130_fd_sc_hd__mux2_1
X_1833_ _0660_ _0832_ VGND VGND VPWR VPWR _0880_ sky130_fd_sc_hd__or2_1
X_1764_ u_uart_tx.state\[0\] _0826_ VGND VGND VPWR VPWR _0827_ sky130_fd_sc_hd__or2_1
X_3503_ clknet_leaf_25_clk _0330_ net136 VGND VGND VPWR VPWR u_parser.u_decoder.timeout_count\[5\]
+ sky130_fd_sc_hd__dfrtp_1
X_3434_ clknet_leaf_16_clk _0267_ VGND VGND VPWR VPWR u_rx_fifo.mem\[1\]\[2\] sky130_fd_sc_hd__dfxtp_1
X_1695_ u_rx_fifo.mem\[8\]\[2\] u_rx_fifo.mem\[9\]\[2\] u_rx_fifo.mem\[10\]\[2\] u_rx_fifo.mem\[11\]\[2\]
+ net151 net147 VGND VGND VPWR VPWR _0762_ sky130_fd_sc_hd__mux4_1
X_3365_ clknet_leaf_48_clk _0198_ net103 VGND VGND VPWR VPWR u_parser.u_packet_encoder.tag_latched\[1\]
+ sky130_fd_sc_hd__dfrtp_1
XFILLER_85_503 VGND VGND VPWR VPWR sky130_fd_sc_hd__fill_1
X_2316_ u_tx_fifo.mem\[12\]\[6\] u_tx_fifo.mem\[13\]\[6\] u_tx_fifo.mem\[14\]\[6\]
+ u_tx_fifo.mem\[15\]\[6\] net68 net64 VGND VGND VPWR VPWR _1120_ sky130_fd_sc_hd__mux4_1
X_3296_ clknet_leaf_1_clk _0132_ VGND VGND VPWR VPWR u_tx_fifo.mem\[5\]\[7\] sky130_fd_sc_hd__dfxtp_1
X_2247_ net171 net22 _1067_ VGND VGND VPWR VPWR _0246_ sky130_fd_sc_hd__mux2_1
XFILLER_38_430 VGND VGND VPWR VPWR sky130_fd_sc_hd__decap_4
XTAP_TAPCELL_ROW_0_201 VGND VPWR sky130_fd_sc_hd__tapvpwrvgnd_1
XTAP_TAPCELL_ROW_84_1003 VGND VPWR sky130_fd_sc_hd__tapvpwrvgnd_1
X_2178_ _1047_ _1051_ VGND VGND VPWR VPWR _1052_ sky130_fd_sc_hd__xnor2_1
XFILLER_53_422 VPWR VGND VPWR VGND sky130_ef_sc_hd__decap_12
XFILLER_80_241 VGND VGND VPWR VPWR sky130_fd_sc_hd__decap_8
XFILLER_40_116 VGND VGND VPWR VPWR sky130_fd_sc_hd__decap_4
XFILLER_53_477 VPWR VGND VPWR VGND sky130_ef_sc_hd__decap_12
XTAP_TAPCELL_ROW_51_689 VGND VPWR sky130_fd_sc_hd__tapvpwrvgnd_1
XFILLER_5_529 VPWR VGND VPWR VGND sky130_ef_sc_hd__decap_12
XFILLER_31_57 VGND VGND VPWR VPWR sky130_fd_sc_hd__decap_8
XFILLER_88_363 VGND VGND VPWR VPWR sky130_fd_sc_hd__fill_1
XFILLER_48_227 VPWR VGND VPWR VGND sky130_ef_sc_hd__decap_12
XFILLER_91_517 VPWR VGND VPWR VGND sky130_ef_sc_hd__decap_12
XPHY_EDGE_ROW_19_Right_19 VGND VGND VPWR VPWR sky130_fd_sc_hd__decap_3
XTAP_TAPCELL_ROW_42_601 VGND VPWR sky130_fd_sc_hd__tapvpwrvgnd_1
XFILLER_71_285 VGND VGND VPWR VPWR sky130_fd_sc_hd__fill_1
XTAP_TAPCELL_ROW_14_336 VGND VPWR sky130_fd_sc_hd__tapvpwrvgnd_1
Xclkbuf_3_1__f_clk clknet_0_clk VGND VGND VPWR VPWR clknet_3_1__leaf_clk sky130_fd_sc_hd__clkbuf_16
XFILLER_8_389 VPWR VGND VPWR VGND sky130_ef_sc_hd__decap_12
XPHY_EDGE_ROW_28_Right_28 VGND VGND VPWR VPWR sky130_fd_sc_hd__decap_3
XFILLER_79_341 VGND VGND VPWR VPWR sky130_fd_sc_hd__fill_1
X_3150_ net59 _1555_ _1575_ _1581_ VGND VGND VPWR VPWR _0635_ sky130_fd_sc_hd__a31o_1
XFILLER_67_503 VGND VGND VPWR VPWR sky130_fd_sc_hd__fill_1
X_3081_ u_uart_rx.sample_div_count\[9\] _1538_ _1513_ VGND VGND VPWR VPWR _1541_ sky130_fd_sc_hd__o21ai_1
X_2101_ tag_raw\[21\] _0978_ VGND VGND VPWR VPWR _0979_ sky130_fd_sc_hd__xnor2_2
X_2032_ net27 net355 _0957_ VGND VGND VPWR VPWR _0141_ sky130_fd_sc_hd__mux2_1
XPHY_EDGE_ROW_37_Right_37 VGND VGND VPWR VPWR sky130_fd_sc_hd__decap_3
XFILLER_15_190 VGND VGND VPWR VPWR sky130_fd_sc_hd__fill_1
X_2934_ u_uart_tx.tx_data\[4\] u_uart_tx.tx_data\[5\] u_uart_tx.tx_data\[6\] u_uart_tx.tx_data\[7\]
+ u_uart_tx.bit_index\[0\] u_uart_tx.bit_index\[1\] VGND VGND VPWR VPWR _1468_ sky130_fd_sc_hd__mux4_1
X_2865_ net23 net362 _1436_ VGND VGND VPWR VPWR _0495_ sky130_fd_sc_hd__mux2_1
XPHY_EDGE_ROW_46_Right_46 VGND VGND VPWR VPWR sky130_fd_sc_hd__decap_3
X_1816_ u_rx_fifo.wr_ptr\[0\] _0848_ VGND VGND VPWR VPWR _0867_ sky130_fd_sc_hd__or2_1
Xhold301 u_parser.u_decoder.decoded_payload\[5\] VGND VGND VPWR VPWR net457 sky130_fd_sc_hd__dlygate4sd3_1
X_2796_ net568 _0779_ _1409_ VGND VGND VPWR VPWR _0453_ sky130_fd_sc_hd__mux2_1
Xhold334 u_uart_rx.rx_shift\[3\] VGND VGND VPWR VPWR net490 sky130_fd_sc_hd__dlygate4sd3_1
Xhold312 u_parser.u_decoder.decoded_payload\[3\] VGND VGND VPWR VPWR net468 sky130_fd_sc_hd__dlygate4sd3_1
Xhold323 u_parser.u_decoder.ascii_buf\[1\]\[3\] VGND VGND VPWR VPWR net479 sky130_fd_sc_hd__dlygate4sd3_1
X_1747_ _0708_ _0796_ VGND VGND VPWR VPWR _0812_ sky130_fd_sc_hd__nor2_1
Xhold356 u_parser.u_packet_encoder.tag_latched\[0\] VGND VGND VPWR VPWR net512 sky130_fd_sc_hd__dlygate4sd3_1
Xhold367 u_parser.u_packet_encoder.tag_latched\[24\] VGND VGND VPWR VPWR net523 sky130_fd_sc_hd__dlygate4sd3_1
Xhold378 u_parser.u_decoder.ascii_buf\[1\]\[6\] VGND VGND VPWR VPWR net534 sky130_fd_sc_hd__dlygate4sd3_1
Xhold345 u_parser.u_decoder.decoded_payload\[11\] VGND VGND VPWR VPWR net501 sky130_fd_sc_hd__dlygate4sd3_1
X_1678_ u_rx_fifo.mem\[8\]\[0\] u_rx_fifo.mem\[9\]\[0\] u_rx_fifo.mem\[10\]\[0\] u_rx_fifo.mem\[11\]\[0\]
+ net151 net147 VGND VGND VPWR VPWR _0745_ sky130_fd_sc_hd__mux4_1
Xhold389 u_parser.u_decoder.ascii_buf\[3\]\[4\] VGND VGND VPWR VPWR net545 sky130_fd_sc_hd__dlygate4sd3_1
X_3417_ clknet_leaf_21_clk _0250_ VGND VGND VPWR VPWR u_rx_fifo.mem\[15\]\[1\] sky130_fd_sc_hd__dfxtp_1
X_3348_ clknet_leaf_37_clk _0181_ net128 VGND VGND VPWR VPWR u_parser.u_decoder.ascii_buf\[11\]\[0\]
+ sky130_fd_sc_hd__dfrtp_1
X_3279_ clknet_leaf_66_clk _0115_ VGND VGND VPWR VPWR u_tx_fifo.mem\[12\]\[6\] sky130_fd_sc_hd__dfxtp_1
XPHY_EDGE_ROW_55_Right_55 VGND VGND VPWR VPWR sky130_fd_sc_hd__decap_3
XTAP_TAPCELL_ROW_56_737 VGND VPWR sky130_fd_sc_hd__tapvpwrvgnd_1
XFILLER_41_447 VGND VGND VPWR VPWR sky130_fd_sc_hd__fill_1
XTAP_TAPCELL_ROW_11_306 VGND VPWR sky130_fd_sc_hd__tapvpwrvgnd_1
XPHY_EDGE_ROW_64_Right_64 VGND VGND VPWR VPWR sky130_fd_sc_hd__decap_3
XFILLER_5_337 VGND VGND VPWR VPWR sky130_fd_sc_hd__decap_6
XFILLER_5_315 VPWR VGND VPWR VGND sky130_ef_sc_hd__decap_12
XPHY_EDGE_ROW_73_Right_73 VGND VGND VPWR VPWR sky130_fd_sc_hd__decap_3
XTAP_TAPCELL_ROW_27_461 VGND VPWR sky130_fd_sc_hd__tapvpwrvgnd_1
XPHY_EDGE_ROW_82_Right_82 VGND VGND VPWR VPWR sky130_fd_sc_hd__decap_3
XFILLER_12_171 VGND VGND VPWR VPWR sky130_fd_sc_hd__decap_3
X_2650_ net444 _1335_ net8 VGND VGND VPWR VPWR _0381_ sky130_fd_sc_hd__mux2_1
XFILLER_8_186 VGND VGND VPWR VPWR sky130_fd_sc_hd__fill_1
X_1601_ u_rx_fifo.rd_ptr\[3\] VGND VGND VPWR VPWR _0671_ sky130_fd_sc_hd__inv_2
X_2581_ u_parser.u_decoder.ascii_buf\[3\]\[1\] u_parser.u_decoder.ascii_buf\[3\]\[2\]
+ u_parser.u_decoder.ascii_buf\[3\]\[3\] VGND VGND VPWR VPWR _1280_ sky130_fd_sc_hd__o21ai_1
XPHY_EDGE_ROW_91_Right_91 VGND VGND VPWR VPWR sky130_fd_sc_hd__decap_3
X_3202_ clknet_leaf_3_clk _0038_ VGND VGND VPWR VPWR u_tx_fifo.mem\[7\]\[1\] sky130_fd_sc_hd__dfxtp_1
X_3133_ net59 _1568_ _1565_ VGND VGND VPWR VPWR _1570_ sky130_fd_sc_hd__a21oi_1
X_3064_ u_uart_rx.sample_div_count\[2\] u_uart_rx.sample_div_count\[3\] u_uart_rx.sample_div_count\[4\]
+ VGND VGND VPWR VPWR _1529_ sky130_fd_sc_hd__and3_1
XFILLER_27_219 VGND VGND VPWR VPWR sky130_fd_sc_hd__decap_4
X_2015_ net26 net279 _0955_ VGND VGND VPWR VPWR _0126_ sky130_fd_sc_hd__mux2_1
XTAP_TAPCELL_ROW_53_707 VGND VPWR sky130_fd_sc_hd__tapvpwrvgnd_1
X_2917_ u_uart_tx.clk_count\[9\] _1456_ VGND VGND VPWR VPWR _1458_ sky130_fd_sc_hd__and2_1
XFILLER_50_299 VGND VGND VPWR VPWR sky130_fd_sc_hd__decap_8
XTAP_TAPCELL_ROW_61_784 VGND VPWR sky130_fd_sc_hd__tapvpwrvgnd_1
X_2848_ _0954_ _1428_ VGND VGND VPWR VPWR _0486_ sky130_fd_sc_hd__nand2_1
X_2779_ net549 _1406_ net12 VGND VGND VPWR VPWR _0439_ sky130_fd_sc_hd__mux2_1
Xhold142 u_rx_fifo.mem\[5\]\[1\] VGND VGND VPWR VPWR net298 sky130_fd_sc_hd__dlygate4sd3_1
Xhold153 u_tx_fifo.mem\[9\]\[6\] VGND VGND VPWR VPWR net309 sky130_fd_sc_hd__dlygate4sd3_1
Xhold120 u_rx_fifo.mem\[9\]\[2\] VGND VGND VPWR VPWR net276 sky130_fd_sc_hd__dlygate4sd3_1
Xhold131 u_rx_fifo.mem\[15\]\[4\] VGND VGND VPWR VPWR net287 sky130_fd_sc_hd__dlygate4sd3_1
Xhold186 u_tx_fifo.mem\[5\]\[6\] VGND VGND VPWR VPWR net342 sky130_fd_sc_hd__dlygate4sd3_1
Xhold175 u_rx_fifo.mem\[8\]\[0\] VGND VGND VPWR VPWR net331 sky130_fd_sc_hd__dlygate4sd3_1
Xhold164 u_rx_fifo.mem\[15\]\[0\] VGND VGND VPWR VPWR net320 sky130_fd_sc_hd__dlygate4sd3_1
Xhold197 u_tx_fifo.mem\[3\]\[0\] VGND VGND VPWR VPWR net353 sky130_fd_sc_hd__dlygate4sd3_1
XFILLER_58_355 VGND VGND VPWR VPWR sky130_fd_sc_hd__decap_8
XFILLER_54_550 VGND VGND VPWR VPWR sky130_fd_sc_hd__decap_4
XFILLER_81_391 VGND VGND VPWR VPWR sky130_fd_sc_hd__fill_1
XFILLER_26_296 VPWR VGND VPWR VGND sky130_ef_sc_hd__decap_12
XTAP_TAPCELL_ROW_24_431 VGND VPWR sky130_fd_sc_hd__tapvpwrvgnd_1
XFILLER_41_266 VGND VGND VPWR VPWR sky130_fd_sc_hd__decap_3
XFILLER_53_55 VGND VGND VPWR VPWR sky130_fd_sc_hd__fill_1
XFILLER_53_77 VGND VGND VPWR VPWR sky130_fd_sc_hd__fill_1
XFILLER_78_85 VGND VGND VPWR VPWR sky130_fd_sc_hd__fill_2
XFILLER_1_384 VGND VGND VPWR VPWR sky130_fd_sc_hd__decap_8
XFILLER_76_141 VGND VGND VPWR VPWR sky130_fd_sc_hd__decap_4
X_3820_ clknet_leaf_18_clk _0636_ net121 VGND VGND VPWR VPWR u_uart_rx.rx_shift\[5\]
+ sky130_fd_sc_hd__dfrtp_1
XFILLER_60_553 VGND VGND VPWR VPWR sky130_fd_sc_hd__fill_2
X_3751_ clknet_leaf_62_clk _0569_ VGND VGND VPWR VPWR u_tx_fifo.mem\[15\]\[0\] sky130_fd_sc_hd__dfxtp_1
X_2702_ net524 net43 _1372_ VGND VGND VPWR VPWR _0396_ sky130_fd_sc_hd__mux2_1
XFILLER_9_473 VPWR VGND VPWR VGND sky130_ef_sc_hd__decap_12
XTAP_TAPCELL_ROW_30_489 VGND VPWR sky130_fd_sc_hd__tapvpwrvgnd_1
X_3682_ clknet_leaf_6_clk _0509_ VGND VGND VPWR VPWR u_tx_fifo.mem\[1\]\[0\] sky130_fd_sc_hd__dfxtp_1
XFILLER_71_3 VPWR VGND VPWR VGND sky130_ef_sc_hd__decap_12
X_2633_ _1318_ _1321_ VGND VGND VPWR VPWR _1322_ sky130_fd_sc_hd__and2_1
X_2564_ u_parser.u_decoder.ascii_buf\[4\]\[3\] _1265_ _1266_ u_parser.u_decoder.ascii_buf\[4\]\[7\]
+ u_parser.u_decoder.ascii_buf\[4\]\[6\] VGND VGND VPWR VPWR _1267_ sky130_fd_sc_hd__a2111oi_1
XFILLER_87_428 VPWR VGND VPWR VGND sky130_ef_sc_hd__decap_12
X_2495_ u_parser.u_decoder.ascii_buf\[8\]\[0\] u_parser.u_decoder.ascii_buf\[8\]\[3\]
+ _1207_ _1213_ VGND VGND VPWR VPWR _1214_ sky130_fd_sc_hd__o31a_1
X_3116_ net433 net71 _0845_ VGND VGND VPWR VPWR _0624_ sky130_fd_sc_hd__mux2_1
XFILLER_55_358 VGND VGND VPWR VPWR sky130_fd_sc_hd__fill_2
XTAP_TAPCELL_ROW_66_832 VGND VPWR sky130_fd_sc_hd__tapvpwrvgnd_1
X_3047_ u_uart_rx.sample_phase\[0\] u_uart_rx.sample_phase\[1\] u_uart_rx.sample_phase\[2\]
+ u_uart_rx.sample_phase\[3\] VGND VGND VPWR VPWR _1518_ sky130_fd_sc_hd__a31o_1
XTAP_TAPCELL_ROW_38_567 VGND VPWR sky130_fd_sc_hd__tapvpwrvgnd_1
XTAP_TAPCELL_ROW_21_401 VGND VPWR sky130_fd_sc_hd__tapvpwrvgnd_1
XFILLER_58_141 VGND VGND VPWR VPWR sky130_fd_sc_hd__decap_3
XPHY_EDGE_ROW_45_Left_139 VGND VGND VPWR VPWR sky130_fd_sc_hd__decap_3
XFILLER_48_77 VGND VGND VPWR VPWR sky130_fd_sc_hd__decap_6
XFILLER_0_29 VPWR VGND VPWR VGND sky130_ef_sc_hd__decap_12
XFILLER_64_65 VGND VGND VPWR VPWR sky130_fd_sc_hd__fill_2
XFILLER_9_27 VGND VGND VPWR VPWR sky130_fd_sc_hd__decap_4
Xfanout70 net71 VGND VGND VPWR VPWR net70 sky130_fd_sc_hd__clkbuf_2
Xfanout81 rx_fifo_in_data\[2\] VGND VGND VPWR VPWR net81 sky130_fd_sc_hd__buf_2
Xfanout92 net94 VGND VGND VPWR VPWR net92 sky130_fd_sc_hd__clkbuf_4
XPHY_EDGE_ROW_54_Left_148 VGND VGND VPWR VPWR sky130_fd_sc_hd__decap_3
XFILLER_6_421 VPWR VGND VPWR VGND sky130_ef_sc_hd__decap_12
XFILLER_89_51 VGND VGND VPWR VPWR sky130_fd_sc_hd__decap_4
XFILLER_69_417 VGND VGND VPWR VPWR sky130_fd_sc_hd__decap_6
X_2280_ u_tx_fifo.mem\[12\]\[2\] u_tx_fifo.mem\[13\]\[2\] u_tx_fifo.mem\[14\]\[2\]
+ u_tx_fifo.mem\[15\]\[2\] net68 net64 VGND VGND VPWR VPWR _1088_ sky130_fd_sc_hd__mux4_1
XPHY_EDGE_ROW_63_Left_157 VGND VGND VPWR VPWR sky130_fd_sc_hd__decap_3
XFILLER_92_475 VGND VGND VPWR VPWR sky130_fd_sc_hd__fill_1
XTAP_TAPCELL_ROW_63_802 VGND VPWR sky130_fd_sc_hd__tapvpwrvgnd_1
XTAP_TAPCELL_ROW_35_537 VGND VPWR sky130_fd_sc_hd__tapvpwrvgnd_1
X_3803_ clknet_leaf_17_clk _0621_ net121 VGND VGND VPWR VPWR rx_fifo_in_data\[4\]
+ sky130_fd_sc_hd__dfrtp_1
XPHY_EDGE_ROW_72_Left_166 VGND VGND VPWR VPWR sky130_fd_sc_hd__decap_3
X_1995_ net305 net27 _0952_ VGND VGND VPWR VPWR _0109_ sky130_fd_sc_hd__mux2_1
XFILLER_60_394 VGND VGND VPWR VPWR sky130_fd_sc_hd__fill_2
X_3734_ clknet_leaf_60_clk _0558_ net89 VGND VGND VPWR VPWR u_uart_tx.bit_index\[0\]
+ sky130_fd_sc_hd__dfrtp_2
X_3665_ clknet_leaf_18_clk _0492_ net120 VGND VGND VPWR VPWR u_rx_fifo.rd_ptr\[3\]
+ sky130_fd_sc_hd__dfrtp_4
Xclkload62 clknet_leaf_30_clk VGND VGND VPWR VPWR clkload62/Y sky130_fd_sc_hd__clkinv_8
X_2616_ net486 _1307_ net9 VGND VGND VPWR VPWR _0375_ sky130_fd_sc_hd__mux2_1
Xclkload51 clknet_leaf_23_clk VGND VGND VPWR VPWR clkload51/Y sky130_fd_sc_hd__inv_6
Xclkload40 clknet_leaf_10_clk VGND VGND VPWR VPWR clkload40/Y sky130_fd_sc_hd__clkinv_4
X_3596_ clknet_leaf_44_clk _0423_ net112 VGND VGND VPWR VPWR u_parser.u_decoder.ascii_buf\[9\]\[7\]
+ sky130_fd_sc_hd__dfrtp_1
XPHY_EDGE_ROW_81_Left_175 VGND VGND VPWR VPWR sky130_fd_sc_hd__decap_3
X_2547_ u_parser.u_decoder.ascii_buf\[5\]\[3\] u_parser.u_decoder.ascii_buf\[5\]\[7\]
+ u_parser.u_decoder.ascii_buf\[5\]\[4\] u_parser.u_decoder.ascii_buf\[5\]\[6\] VGND
+ VGND VPWR VPWR _1254_ sky130_fd_sc_hd__or4b_1
X_2478_ net436 _1200_ net10 VGND VGND VPWR VPWR _0344_ sky130_fd_sc_hd__mux2_1
XFILLER_87_258 VGND VGND VPWR VPWR sky130_fd_sc_hd__fill_1
XFILLER_55_155 VGND VGND VPWR VPWR sky130_fd_sc_hd__decap_4
XFILLER_83_486 VPWR VGND VPWR VGND sky130_ef_sc_hd__decap_12
XFILLER_70_125 VGND VGND VPWR VPWR sky130_fd_sc_hd__decap_6
XPHY_EDGE_ROW_90_Left_184 VGND VGND VPWR VPWR sky130_fd_sc_hd__decap_3
XFILLER_24_553 VGND VGND VPWR VPWR sky130_fd_sc_hd__fill_2
XFILLER_51_350 VGND VGND VPWR VPWR sky130_fd_sc_hd__decap_8
XFILLER_7_229 VGND VGND VPWR VPWR sky130_fd_sc_hd__fill_1
Xclkload1 clknet_3_2__leaf_clk VGND VGND VPWR VPWR clkload1/Y sky130_fd_sc_hd__bufinv_16
XFILLER_1_3 VPWR VGND VPWR VGND sky130_ef_sc_hd__decap_12
XTAP_TAPCELL_ROW_6_262 VGND VPWR sky130_fd_sc_hd__tapvpwrvgnd_1
XPHY_EDGE_ROW_3_Left_97 VGND VGND VPWR VPWR sky130_fd_sc_hd__decap_3
XFILLER_19_314 VGND VGND VPWR VPWR sky130_fd_sc_hd__decap_4
XFILLER_46_133 VGND VGND VPWR VPWR sky130_fd_sc_hd__decap_6
XFILLER_46_166 VGND VGND VPWR VPWR sky130_fd_sc_hd__decap_4
XFILLER_34_317 VGND VGND VPWR VPWR sky130_fd_sc_hd__decap_4
XFILLER_27_391 VGND VGND VPWR VPWR sky130_fd_sc_hd__fill_1
XTAP_TAPCELL_ROW_32_507 VGND VPWR sky130_fd_sc_hd__tapvpwrvgnd_1
XFILLER_30_545 VGND VGND VPWR VPWR sky130_fd_sc_hd__decap_8
X_1780_ u_uart_rx.low_count\[6\] u_uart_rx.low_count\[5\] _0839_ _0838_ u_uart_rx.low_count\[13\]
+ VGND VGND VPWR VPWR _0840_ sky130_fd_sc_hd__o311a_1
XTAP_TAPCELL_ROW_40_584 VGND VPWR sky130_fd_sc_hd__tapvpwrvgnd_1
XFILLER_6_284 VPWR VGND VPWR VGND sky130_ef_sc_hd__decap_12
X_3450_ clknet_leaf_59_clk _0277_ net90 VGND VGND VPWR VPWR tag_raw\[4\] sky130_fd_sc_hd__dfrtp_1
X_3381_ clknet_leaf_46_clk _0214_ net102 VGND VGND VPWR VPWR u_parser.u_packet_encoder.tag_latched\[17\]
+ sky130_fd_sc_hd__dfrtp_1
X_2401_ _0784_ _0818_ _1145_ VGND VGND VPWR VPWR _1147_ sky130_fd_sc_hd__and3_1
X_2332_ net82 net416 _1132_ VGND VGND VPWR VPWR _0266_ sky130_fd_sc_hd__mux2_1
XFILLER_34_3 VPWR VGND VPWR VGND sky130_ef_sc_hd__decap_12
XFILLER_84_206 VGND VGND VPWR VPWR sky130_fd_sc_hd__decap_3
X_2263_ _0681_ _1072_ VGND VGND VPWR VPWR _1073_ sky130_fd_sc_hd__or2_1
X_2194_ net525 net574 net55 VGND VGND VPWR VPWR _0198_ sky130_fd_sc_hd__mux2_1
XFILLER_37_111 VGND VGND VPWR VPWR sky130_fd_sc_hd__fill_1
XFILLER_92_261 VGND VGND VPWR VPWR sky130_fd_sc_hd__fill_1
XFILLER_25_306 VGND VGND VPWR VPWR sky130_fd_sc_hd__fill_2
XTAP_TAPCELL_ROW_48_662 VGND VPWR sky130_fd_sc_hd__tapvpwrvgnd_1
XFILLER_25_328 VGND VGND VPWR VPWR sky130_fd_sc_hd__decap_8
XFILLER_52_169 VGND VGND VPWR VPWR sky130_fd_sc_hd__decap_8
XFILLER_21_534 VPWR VGND VPWR VGND sky130_ef_sc_hd__decap_12
X_1978_ net78 net380 _0948_ VGND VGND VPWR VPWR _0096_ sky130_fd_sc_hd__mux2_1
X_3717_ clknet_leaf_32_clk _0541_ net141 VGND VGND VPWR VPWR u_uart_rx.low_count\[7\]
+ sky130_fd_sc_hd__dfrtp_1
XFILLER_20_15 VGND VGND VPWR VPWR sky130_fd_sc_hd__decap_4
X_3648_ clknet_leaf_8_clk _0475_ net116 VGND VGND VPWR VPWR u_parser.u_decoder.ascii_buf\[4\]\[3\]
+ sky130_fd_sc_hd__dfrtp_1
X_3579_ clknet_leaf_25_clk _0406_ net128 VGND VGND VPWR VPWR u_parser.u_decoder.ascii_buf\[10\]\[6\]
+ sky130_fd_sc_hd__dfrtp_1
XTAP_TAPCELL_ROW_93_1093 VGND VPWR sky130_fd_sc_hd__tapvpwrvgnd_1
XTAP_TAPCELL_ROW_93_1082 VGND VPWR sky130_fd_sc_hd__tapvpwrvgnd_1
XFILLER_0_405 VPWR VGND VPWR VGND sky130_ef_sc_hd__decap_12
XFILLER_88_545 VGND VGND VPWR VPWR sky130_fd_sc_hd__decap_8
Xhold13 u_tx_fifo.mem\[14\]\[0\] VGND VGND VPWR VPWR net169 sky130_fd_sc_hd__dlygate4sd3_1
XFILLER_0_449 VPWR VGND VPWR VGND sky130_ef_sc_hd__decap_12
Xhold46 u_rx_fifo.mem\[2\]\[6\] VGND VGND VPWR VPWR net202 sky130_fd_sc_hd__dlygate4sd3_1
Xhold35 u_tx_fifo.mem\[2\]\[0\] VGND VGND VPWR VPWR net191 sky130_fd_sc_hd__dlygate4sd3_1
Xhold24 u_rx_fifo.mem\[14\]\[3\] VGND VGND VPWR VPWR net180 sky130_fd_sc_hd__dlygate4sd3_1
XTAP_TAPCELL_ROW_3_232 VGND VPWR sky130_fd_sc_hd__tapvpwrvgnd_1
Xhold68 u_tx_fifo.mem\[12\]\[7\] VGND VGND VPWR VPWR net224 sky130_fd_sc_hd__dlygate4sd3_1
Xhold57 u_rx_fifo.mem\[8\]\[3\] VGND VGND VPWR VPWR net213 sky130_fd_sc_hd__dlygate4sd3_1
Xhold79 u_rx_fifo.mem\[12\]\[1\] VGND VGND VPWR VPWR net235 sky130_fd_sc_hd__dlygate4sd3_1
XTAP_TAPCELL_ROW_74_908 VGND VPWR sky130_fd_sc_hd__tapvpwrvgnd_1
XFILLER_71_467 VGND VGND VPWR VPWR sky130_fd_sc_hd__fill_1
XTAP_TAPCELL_ROW_82_985 VGND VPWR sky130_fd_sc_hd__tapvpwrvgnd_1
XFILLER_12_501 VPWR VGND VPWR VGND sky130_ef_sc_hd__decap_12
XFILLER_43_169 VGND VGND VPWR VPWR sky130_fd_sc_hd__fill_1
XFILLER_12_545 VGND VGND VPWR VPWR sky130_fd_sc_hd__decap_8
XFILLER_61_55 VGND VGND VPWR VPWR sky130_fd_sc_hd__fill_1
XFILLER_86_85 VGND VGND VPWR VPWR sky130_fd_sc_hd__decap_8
XFILLER_19_199 VGND VGND VPWR VPWR sky130_fd_sc_hd__fill_1
XTAP_TAPCELL_ROW_45_632 VGND VPWR sky130_fd_sc_hd__tapvpwrvgnd_1
X_2950_ u_uart_rx.low_count\[5\] _1476_ net86 VGND VGND VPWR VPWR _1478_ sky130_fd_sc_hd__a21oi_1
XTAP_TAPCELL_ROW_17_367 VGND VPWR sky130_fd_sc_hd__tapvpwrvgnd_1
XFILLER_22_309 VGND VGND VPWR VPWR sky130_fd_sc_hd__decap_3
X_1901_ _0911_ _0924_ _0926_ _0904_ u_parser.u_packet_encoder.crc_latched\[4\] VGND
+ VGND VPWR VPWR _0927_ sky130_fd_sc_hd__o32a_1
X_2881_ net28 net402 _1438_ VGND VGND VPWR VPWR _0509_ sky130_fd_sc_hd__mux2_1
X_1832_ u_parser.u_packet_encoder.byte_index\[2\] _0878_ u_parser.u_packet_encoder.byte_index\[3\]
+ VGND VGND VPWR VPWR _0879_ sky130_fd_sc_hd__or3b_1
XFILLER_30_342 VGND VGND VPWR VPWR sky130_fd_sc_hd__decap_4
X_1763_ _0661_ u_uart_tx.state\[1\] VGND VGND VPWR VPWR _0826_ sky130_fd_sc_hd__nand2_1
X_3502_ clknet_leaf_28_clk _0329_ net136 VGND VGND VPWR VPWR u_parser.u_decoder.timeout_count\[4\]
+ sky130_fd_sc_hd__dfrtp_1
X_1694_ u_rx_fifo.mem\[12\]\[2\] u_rx_fifo.mem\[13\]\[2\] u_rx_fifo.mem\[14\]\[2\]
+ u_rx_fifo.mem\[15\]\[2\] net152 net148 VGND VGND VPWR VPWR _0761_ sky130_fd_sc_hd__mux4_1
X_3433_ clknet_leaf_17_clk _0266_ VGND VGND VPWR VPWR u_rx_fifo.mem\[1\]\[1\] sky130_fd_sc_hd__dfxtp_1
X_3364_ clknet_leaf_51_clk _0197_ net94 VGND VGND VPWR VPWR u_parser.u_packet_encoder.tag_latched\[0\]
+ sky130_fd_sc_hd__dfrtp_1
X_2315_ u_tx_fifo.mem\[8\]\[6\] u_tx_fifo.mem\[9\]\[6\] u_tx_fifo.mem\[10\]\[6\] u_tx_fifo.mem\[11\]\[6\]
+ net66 net62 VGND VGND VPWR VPWR _1119_ sky130_fd_sc_hd__mux4_1
X_3295_ clknet_leaf_2_clk _0131_ VGND VGND VPWR VPWR u_tx_fifo.mem\[5\]\[6\] sky130_fd_sc_hd__dfxtp_1
X_2246_ net215 net31 _1067_ VGND VGND VPWR VPWR _0245_ sky130_fd_sc_hd__mux2_1
XTAP_TAPCELL_ROW_0_202 VGND VPWR sky130_fd_sc_hd__tapvpwrvgnd_1
XTAP_TAPCELL_ROW_84_1004 VGND VPWR sky130_fd_sc_hd__tapvpwrvgnd_1
X_2177_ tag_raw\[4\] _1024_ VGND VGND VPWR VPWR _1051_ sky130_fd_sc_hd__xnor2_1
XFILLER_38_475 VGND VGND VPWR VPWR sky130_fd_sc_hd__fill_1
XFILLER_53_401 VGND VGND VPWR VPWR sky130_fd_sc_hd__decap_4
XFILLER_53_434 VGND VGND VPWR VPWR sky130_fd_sc_hd__decap_4
XFILLER_65_294 VGND VGND VPWR VPWR sky130_fd_sc_hd__fill_1
XFILLER_80_253 VGND VGND VPWR VPWR sky130_fd_sc_hd__decap_3
XFILLER_53_489 VGND VGND VPWR VPWR sky130_fd_sc_hd__decap_6
XFILLER_88_320 VGND VGND VPWR VPWR sky130_fd_sc_hd__fill_1
XFILLER_76_515 VPWR VGND VPWR VGND sky130_ef_sc_hd__decap_12
XFILLER_48_239 VPWR VGND VPWR VGND sky130_ef_sc_hd__decap_12
XFILLER_29_464 VGND VGND VPWR VPWR sky130_fd_sc_hd__fill_1
XFILLER_91_529 VPWR VGND VPWR VGND sky130_ef_sc_hd__decap_12
XFILLER_56_283 VPWR VGND VPWR VGND sky130_ef_sc_hd__decap_12
XFILLER_44_434 VPWR VGND VPWR VGND sky130_ef_sc_hd__decap_12
XTAP_TAPCELL_ROW_42_602 VGND VPWR sky130_fd_sc_hd__tapvpwrvgnd_1
XFILLER_44_489 VPWR VGND VPWR VGND sky130_ef_sc_hd__decap_12
XFILLER_71_264 VGND VGND VPWR VPWR sky130_fd_sc_hd__decap_8
XTAP_TAPCELL_ROW_14_337 VGND VPWR sky130_fd_sc_hd__tapvpwrvgnd_1
X_3080_ u_uart_rx.sample_div_count\[9\] _1538_ VGND VGND VPWR VPWR _1540_ sky130_fd_sc_hd__and2_1
X_2100_ _0974_ _0977_ VGND VGND VPWR VPWR _0978_ sky130_fd_sc_hd__xnor2_1
X_2031_ _0951_ _0954_ VGND VGND VPWR VPWR _0957_ sky130_fd_sc_hd__or2_4
XFILLER_54_209 VGND VGND VPWR VPWR sky130_fd_sc_hd__fill_1
XFILLER_35_434 VGND VGND VPWR VPWR sky130_fd_sc_hd__fill_1
XFILLER_62_242 VGND VGND VPWR VPWR sky130_fd_sc_hd__fill_1
X_2933_ u_uart_tx.bit_index\[2\] _1466_ VGND VGND VPWR VPWR _1467_ sky130_fd_sc_hd__and2b_1
XFILLER_62_297 VGND VGND VPWR VPWR sky130_fd_sc_hd__decap_8
X_2864_ net25 net368 _1436_ VGND VGND VPWR VPWR _0494_ sky130_fd_sc_hd__mux2_1
X_2795_ net548 net43 _1409_ VGND VGND VPWR VPWR _0452_ sky130_fd_sc_hd__mux2_1
X_1815_ u_rx_fifo.wr_ptr\[0\] _0848_ VGND VGND VPWR VPWR _0866_ sky130_fd_sc_hd__nand2_1
Xhold302 u_parser.u_decoder.decoded_payload\[36\] VGND VGND VPWR VPWR net458 sky130_fd_sc_hd__dlygate4sd3_1
X_1746_ _0798_ _0801_ _0804_ _0811_ VGND VGND VPWR VPWR _0008_ sky130_fd_sc_hd__and4_1
Xhold313 _0276_ VGND VGND VPWR VPWR net469 sky130_fd_sc_hd__dlygate4sd3_1
Xhold335 u_parser.u_packet_encoder.tag_latched\[5\] VGND VGND VPWR VPWR net491 sky130_fd_sc_hd__dlygate4sd3_1
Xhold324 tag_raw\[29\] VGND VGND VPWR VPWR net480 sky130_fd_sc_hd__dlygate4sd3_1
Xhold346 tag_raw\[10\] VGND VGND VPWR VPWR net502 sky130_fd_sc_hd__dlygate4sd3_1
Xhold357 u_parser.u_packet_encoder.tag_latched\[25\] VGND VGND VPWR VPWR net513 sky130_fd_sc_hd__dlygate4sd3_1
Xhold368 u_parser.u_decoder.ascii_buf\[6\]\[4\] VGND VGND VPWR VPWR net524 sky130_fd_sc_hd__dlygate4sd3_1
X_1677_ _0737_ _0739_ _0742_ _0671_ VGND VGND VPWR VPWR _0744_ sky130_fd_sc_hd__a22o_2
Xhold379 u_uart_rx.rx_shift\[1\] VGND VGND VPWR VPWR net535 sky130_fd_sc_hd__dlygate4sd3_1
X_3416_ clknet_leaf_21_clk _0249_ VGND VGND VPWR VPWR u_rx_fifo.mem\[15\]\[0\] sky130_fd_sc_hd__dfxtp_1
XTAP_TAPCELL_ROW_90_1052 VGND VPWR sky130_fd_sc_hd__tapvpwrvgnd_1
X_3347_ clknet_leaf_6_clk _0180_ VGND VGND VPWR VPWR u_tx_fifo.mem\[3\]\[7\] sky130_fd_sc_hd__dfxtp_1
X_3278_ clknet_leaf_65_clk _0114_ VGND VGND VPWR VPWR u_tx_fifo.mem\[12\]\[5\] sky130_fd_sc_hd__dfxtp_1
XFILLER_73_518 VGND VGND VPWR VPWR sky130_fd_sc_hd__fill_2
X_2229_ tag_raw\[36\] net537 net53 VGND VGND VPWR VPWR _0233_ sky130_fd_sc_hd__mux2_1
XTAP_TAPCELL_ROW_56_738 VGND VPWR sky130_fd_sc_hd__tapvpwrvgnd_1
XFILLER_26_434 VGND VGND VPWR VPWR sky130_fd_sc_hd__decap_8
XFILLER_26_58 VGND VGND VPWR VPWR sky130_fd_sc_hd__fill_1
XTAP_TAPCELL_ROW_11_307 VGND VPWR sky130_fd_sc_hd__tapvpwrvgnd_1
XFILLER_5_327 VGND VGND VPWR VPWR sky130_fd_sc_hd__decap_6
XFILLER_17_401 VPWR VGND VPWR VGND sky130_ef_sc_hd__decap_12
XTAP_TAPCELL_ROW_27_462 VGND VPWR sky130_fd_sc_hd__tapvpwrvgnd_1
XFILLER_32_415 VGND VGND VPWR VPWR sky130_fd_sc_hd__decap_4
XFILLER_44_253 VGND VGND VPWR VPWR sky130_fd_sc_hd__decap_6
XFILLER_12_183 VGND VGND VPWR VPWR sky130_fd_sc_hd__fill_1
X_1600_ net145 VGND VGND VPWR VPWR _0670_ sky130_fd_sc_hd__inv_2
X_2580_ net427 _1279_ net8 VGND VGND VPWR VPWR _0367_ sky130_fd_sc_hd__mux2_1
X_3201_ clknet_leaf_5_clk _0037_ VGND VGND VPWR VPWR u_tx_fifo.mem\[7\]\[0\] sky130_fd_sc_hd__dfxtp_1
X_3132_ _1568_ _1569_ VGND VGND VPWR VPWR _0629_ sky130_fd_sc_hd__nor2_1
X_3063_ _1513_ _1527_ _1528_ VGND VGND VPWR VPWR _0601_ sky130_fd_sc_hd__and3_1
X_2014_ net27 net185 _0955_ VGND VGND VPWR VPWR _0125_ sky130_fd_sc_hd__mux2_1
XFILLER_35_242 VGND VGND VPWR VPWR sky130_fd_sc_hd__decap_4
XTAP_TAPCELL_ROW_53_708 VGND VPWR sky130_fd_sc_hd__tapvpwrvgnd_1
XFILLER_23_415 VPWR VGND VPWR VGND sky130_ef_sc_hd__decap_12
X_2916_ _1456_ _1457_ VGND VGND VPWR VPWR _0525_ sky130_fd_sc_hd__nor2_1
XTAP_TAPCELL_ROW_61_785 VGND VPWR sky130_fd_sc_hd__tapvpwrvgnd_1
X_2847_ u_tx_fifo.wr_ptr\[0\] _0881_ u_tx_fifo.wr_ptr\[1\] VGND VGND VPWR VPWR _1428_
+ sky130_fd_sc_hd__a21bo_1
Xhold110 u_rx_fifo.mem\[12\]\[4\] VGND VGND VPWR VPWR net266 sky130_fd_sc_hd__dlygate4sd3_1
X_2778_ u_parser.u_decoder.ascii_buf\[10\]\[3\] _1397_ _1394_ VGND VGND VPWR VPWR
+ _1406_ sky130_fd_sc_hd__a21o_1
Xhold121 u_tx_fifo.mem\[11\]\[2\] VGND VGND VPWR VPWR net277 sky130_fd_sc_hd__dlygate4sd3_1
Xhold143 u_tx_fifo.mem\[9\]\[3\] VGND VGND VPWR VPWR net299 sky130_fd_sc_hd__dlygate4sd3_1
Xhold132 u_tx_fifo.mem\[13\]\[4\] VGND VGND VPWR VPWR net288 sky130_fd_sc_hd__dlygate4sd3_1
X_1729_ _0735_ net40 _0795_ VGND VGND VPWR VPWR _0796_ sky130_fd_sc_hd__nor3_1
Xhold154 u_rx_fifo.mem\[4\]\[0\] VGND VGND VPWR VPWR net310 sky130_fd_sc_hd__dlygate4sd3_1
Xhold176 u_tx_fifo.mem\[15\]\[1\] VGND VGND VPWR VPWR net332 sky130_fd_sc_hd__dlygate4sd3_1
Xhold165 u_tx_fifo.mem\[5\]\[3\] VGND VGND VPWR VPWR net321 sky130_fd_sc_hd__dlygate4sd3_1
Xhold187 u_rx_fifo.mem\[1\]\[7\] VGND VGND VPWR VPWR net343 sky130_fd_sc_hd__dlygate4sd3_1
Xhold198 u_rx_fifo.mem\[9\]\[5\] VGND VGND VPWR VPWR net354 sky130_fd_sc_hd__dlygate4sd3_1
XFILLER_58_301 VGND VGND VPWR VPWR sky130_fd_sc_hd__fill_1
XFILLER_85_142 VGND VGND VPWR VPWR sky130_fd_sc_hd__fill_1
XFILLER_37_57 VGND VGND VPWR VPWR sky130_fd_sc_hd__decap_4
XFILLER_58_389 VPWR VGND VPWR VGND sky130_ef_sc_hd__decap_12
XFILLER_73_315 VGND VGND VPWR VPWR sky130_fd_sc_hd__decap_6
XTAP_TAPCELL_ROW_24_432 VGND VPWR sky130_fd_sc_hd__tapvpwrvgnd_1
XFILLER_41_278 VGND VGND VPWR VPWR sky130_fd_sc_hd__fill_2
XFILLER_78_75 VGND VGND VPWR VPWR sky130_fd_sc_hd__decap_4
XFILLER_89_481 VPWR VGND VPWR VGND sky130_ef_sc_hd__decap_12
XFILLER_76_197 VPWR VGND VPWR VGND sky130_ef_sc_hd__decap_12
XFILLER_17_220 VGND VGND VPWR VPWR sky130_fd_sc_hd__decap_4
XFILLER_20_418 VGND VGND VPWR VPWR sky130_fd_sc_hd__fill_2
XFILLER_20_429 VGND VGND VPWR VPWR sky130_fd_sc_hd__decap_3
X_3750_ clknet_leaf_34_clk net1 net134 VGND VGND VPWR VPWR u_rx_sync.sync_ff1 sky130_fd_sc_hd__dfstp_1
XFILLER_13_481 VPWR VGND VPWR VGND sky130_ef_sc_hd__decap_12
XFILLER_9_441 VGND VGND VPWR VPWR sky130_fd_sc_hd__decap_6
X_2701_ u_parser.u_decoder.ascii_buf\[6\]\[3\] net44 _1372_ VGND VGND VPWR VPWR _0395_
+ sky130_fd_sc_hd__mux2_1
XFILLER_9_485 VPWR VGND VPWR VGND sky130_ef_sc_hd__decap_12
X_3681_ clknet_leaf_64_clk _0508_ VGND VGND VPWR VPWR u_tx_fifo.mem\[10\]\[7\] sky130_fd_sc_hd__dfxtp_1
X_2632_ u_parser.u_decoder.ascii_buf\[1\]\[0\] u_parser.u_decoder.ascii_buf\[1\]\[1\]
+ _1310_ u_parser.u_decoder.ascii_buf\[1\]\[2\] VGND VGND VPWR VPWR _1321_ sky130_fd_sc_hd__a31o_1
XFILLER_64_3 VPWR VGND VPWR VGND sky130_ef_sc_hd__decap_12
X_2563_ u_parser.u_decoder.ascii_buf\[4\]\[4\] u_parser.u_decoder.ascii_buf\[4\]\[5\]
+ VGND VGND VPWR VPWR _1266_ sky130_fd_sc_hd__nand2_1
X_2494_ u_parser.u_decoder.ascii_buf\[8\]\[0\] u_parser.u_decoder.ascii_buf\[8\]\[1\]
+ u_parser.u_decoder.ascii_buf\[8\]\[2\] _1212_ VGND VGND VPWR VPWR _1213_ sky130_fd_sc_hd__a31oi_1
X_3115_ net527 net72 _0845_ VGND VGND VPWR VPWR _0623_ sky130_fd_sc_hd__mux2_1
X_3046_ u_uart_rx.sample_phase\[2\] _1515_ _1517_ _1514_ VGND VGND VPWR VPWR _0595_
+ sky130_fd_sc_hd__a22o_1
XTAP_TAPCELL_ROW_66_833 VGND VPWR sky130_fd_sc_hd__tapvpwrvgnd_1
XFILLER_23_223 VGND VGND VPWR VPWR sky130_fd_sc_hd__fill_1
XFILLER_51_554 VGND VGND VPWR VPWR sky130_fd_sc_hd__fill_1
XTAP_TAPCELL_ROW_21_402 VGND VPWR sky130_fd_sc_hd__tapvpwrvgnd_1
XFILLER_58_153 VGND VGND VPWR VPWR sky130_fd_sc_hd__decap_3
XFILLER_58_197 VGND VGND VPWR VPWR sky130_fd_sc_hd__fill_1
XFILLER_9_39 VGND VGND VPWR VPWR sky130_fd_sc_hd__decap_4
Xfanout82 net83 VGND VGND VPWR VPWR net82 sky130_fd_sc_hd__clkbuf_2
Xfanout71 rx_fifo_in_data\[7\] VGND VGND VPWR VPWR net71 sky130_fd_sc_hd__buf_2
Xfanout60 net61 VGND VGND VPWR VPWR net60 sky130_fd_sc_hd__buf_2
Xfanout93 net94 VGND VGND VPWR VPWR net93 sky130_fd_sc_hd__clkbuf_4
XFILLER_6_433 VPWR VGND VPWR VGND sky130_ef_sc_hd__decap_12
XFILLER_6_477 VPWR VGND VPWR VGND sky130_ef_sc_hd__decap_12
XFILLER_89_63 VGND VGND VPWR VPWR sky130_fd_sc_hd__fill_1
XFILLER_92_421 VGND VGND VPWR VPWR sky130_fd_sc_hd__decap_8
XTAP_TAPCELL_ROW_63_803 VGND VPWR sky130_fd_sc_hd__tapvpwrvgnd_1
XTAP_TAPCELL_ROW_35_538 VGND VPWR sky130_fd_sc_hd__tapvpwrvgnd_1
XFILLER_52_318 VGND VGND VPWR VPWR sky130_fd_sc_hd__decap_6
X_3802_ clknet_leaf_17_clk _0620_ net121 VGND VGND VPWR VPWR rx_fifo_in_data\[3\]
+ sky130_fd_sc_hd__dfrtp_1
X_1994_ _0950_ _0951_ VGND VGND VPWR VPWR _0952_ sky130_fd_sc_hd__nor2_4
XTAP_TAPCELL_ROW_71_880 VGND VPWR sky130_fd_sc_hd__tapvpwrvgnd_1
X_3733_ clknet_leaf_31_clk _0557_ net142 VGND VGND VPWR VPWR u_uart_rx.low_count\[23\]
+ sky130_fd_sc_hd__dfrtp_1
X_3664_ clknet_leaf_19_clk _0491_ net120 VGND VGND VPWR VPWR u_rx_fifo.rd_ptr\[2\]
+ sky130_fd_sc_hd__dfrtp_1
Xclkload30 clknet_leaf_54_clk VGND VGND VPWR VPWR clkload30/Y sky130_fd_sc_hd__inv_8
Xclkload41 clknet_leaf_11_clk VGND VGND VPWR VPWR clkload41/Y sky130_fd_sc_hd__clkinv_4
X_2615_ u_parser.u_decoder.ascii_buf\[2\]\[3\] _1296_ _1299_ VGND VGND VPWR VPWR _1307_
+ sky130_fd_sc_hd__a21o_1
Xclkload52 clknet_leaf_24_clk VGND VGND VPWR VPWR clkload52/Y sky130_fd_sc_hd__clkinvlp_4
Xclkload63 clknet_leaf_31_clk VGND VGND VPWR VPWR clkload63/Y sky130_fd_sc_hd__inv_6
X_3595_ clknet_leaf_44_clk _0422_ net111 VGND VGND VPWR VPWR u_parser.u_decoder.ascii_buf\[9\]\[6\]
+ sky130_fd_sc_hd__dfrtp_1
X_2546_ u_parser.u_decoder.ascii_buf\[5\]\[4\] u_parser.u_decoder.ascii_buf\[5\]\[5\]
+ _1251_ _1252_ VGND VGND VPWR VPWR _1253_ sky130_fd_sc_hd__and4_1
X_2477_ u_parser.u_decoder.ascii_buf\[9\]\[0\] _1199_ _1196_ VGND VGND VPWR VPWR _1200_
+ sky130_fd_sc_hd__o21a_1
XTAP_TAPCELL_ROW_87_1024 VGND VPWR sky130_fd_sc_hd__tapvpwrvgnd_1
XFILLER_83_498 VGND VGND VPWR VPWR sky130_fd_sc_hd__decap_6
X_3029_ net200 net78 _1507_ VGND VGND VPWR VPWR _0588_ sky130_fd_sc_hd__mux2_1
XFILLER_43_318 VGND VGND VPWR VPWR sky130_fd_sc_hd__decap_6
XFILLER_7_219 VGND VGND VPWR VPWR sky130_fd_sc_hd__decap_4
Xclkload2 clknet_3_3__leaf_clk VGND VGND VPWR VPWR clkload2/Y sky130_fd_sc_hd__clkinvlp_4
XFILLER_3_447 VGND VGND VPWR VPWR sky130_fd_sc_hd__fill_1
XFILLER_59_55 VGND VGND VPWR VPWR sky130_fd_sc_hd__fill_1
XTAP_TAPCELL_ROW_6_263 VGND VPWR sky130_fd_sc_hd__tapvpwrvgnd_1
XFILLER_46_156 VGND VGND VPWR VPWR sky130_fd_sc_hd__fill_2
XFILLER_15_554 VGND VGND VPWR VPWR sky130_fd_sc_hd__fill_1
XTAP_TAPCELL_ROW_32_508 VGND VPWR sky130_fd_sc_hd__tapvpwrvgnd_1
XFILLER_10_270 VGND VGND VPWR VPWR sky130_fd_sc_hd__decap_3
XTAP_TAPCELL_ROW_40_585 VGND VPWR sky130_fd_sc_hd__tapvpwrvgnd_1
XFILLER_10_281 VGND VGND VPWR VPWR sky130_fd_sc_hd__decap_3
XFILLER_6_241 VGND VGND VPWR VPWR sky130_fd_sc_hd__decap_8
XFILLER_6_296 VGND VGND VPWR VPWR sky130_fd_sc_hd__decap_4
X_2400_ _0818_ _1145_ VGND VGND VPWR VPWR _1146_ sky130_fd_sc_hd__nand2_1
X_3380_ clknet_leaf_42_clk _0213_ net109 VGND VGND VPWR VPWR u_parser.u_packet_encoder.tag_latched\[16\]
+ sky130_fd_sc_hd__dfrtp_1
X_2331_ net84 net359 _1132_ VGND VGND VPWR VPWR _0265_ sky130_fd_sc_hd__mux2_1
X_2262_ u_tx_fifo.mem\[12\]\[0\] u_tx_fifo.mem\[13\]\[0\] u_tx_fifo.mem\[14\]\[0\]
+ u_tx_fifo.mem\[15\]\[0\] net67 net63 VGND VGND VPWR VPWR _1072_ sky130_fd_sc_hd__mux4_1
XFILLER_27_3 VPWR VGND VPWR VGND sky130_ef_sc_hd__decap_12
X_2193_ tag_raw\[0\] net512 net52 VGND VGND VPWR VPWR _0197_ sky130_fd_sc_hd__mux2_1
XFILLER_65_410 VGND VGND VPWR VPWR sky130_fd_sc_hd__decap_3
XFILLER_80_435 VGND VGND VPWR VPWR sky130_fd_sc_hd__decap_4
XFILLER_52_159 VGND VGND VPWR VPWR sky130_fd_sc_hd__fill_1
XFILLER_33_351 VPWR VGND VPWR VGND sky130_ef_sc_hd__decap_12
XFILLER_21_546 VGND VGND VPWR VPWR sky130_fd_sc_hd__decap_8
X_3716_ clknet_leaf_33_clk _0540_ net141 VGND VGND VPWR VPWR u_uart_rx.low_count\[6\]
+ sky130_fd_sc_hd__dfrtp_1
X_1977_ net80 net373 _0948_ VGND VGND VPWR VPWR _0095_ sky130_fd_sc_hd__mux2_1
XFILLER_20_38 VPWR VGND VPWR VGND sky130_ef_sc_hd__decap_12
X_3647_ clknet_leaf_7_clk _0474_ net95 VGND VGND VPWR VPWR u_parser.u_decoder.ascii_buf\[4\]\[2\]
+ sky130_fd_sc_hd__dfrtp_1
X_3578_ clknet_leaf_37_clk _0405_ net128 VGND VGND VPWR VPWR u_parser.u_decoder.ascii_buf\[10\]\[5\]
+ sky130_fd_sc_hd__dfrtp_1
XTAP_TAPCELL_ROW_93_1094 VGND VPWR sky130_fd_sc_hd__tapvpwrvgnd_1
XTAP_TAPCELL_ROW_93_1083 VGND VPWR sky130_fd_sc_hd__tapvpwrvgnd_1
XFILLER_0_417 VGND VGND VPWR VPWR sky130_fd_sc_hd__decap_3
X_2529_ _1239_ u_parser.u_decoder.ascii_buf\[6\]\[0\] VGND VGND VPWR VPWR _1240_ sky130_fd_sc_hd__nand2b_1
Xhold14 u_tx_fifo.mem\[8\]\[7\] VGND VGND VPWR VPWR net170 sky130_fd_sc_hd__dlygate4sd3_1
Xhold36 u_rx_fifo.mem\[0\]\[2\] VGND VGND VPWR VPWR net192 sky130_fd_sc_hd__dlygate4sd3_1
Xhold47 u_tx_fifo.mem\[12\]\[3\] VGND VGND VPWR VPWR net203 sky130_fd_sc_hd__dlygate4sd3_1
Xhold25 u_tx_fifo.mem\[4\]\[3\] VGND VGND VPWR VPWR net181 sky130_fd_sc_hd__dlygate4sd3_1
XFILLER_29_69 VGND VGND VPWR VPWR sky130_fd_sc_hd__decap_3
Xhold58 u_tx_fifo.mem\[8\]\[1\] VGND VGND VPWR VPWR net214 sky130_fd_sc_hd__dlygate4sd3_1
XTAP_TAPCELL_ROW_3_233 VGND VPWR sky130_fd_sc_hd__tapvpwrvgnd_1
Xhold69 u_tx_fifo.mem\[4\]\[0\] VGND VGND VPWR VPWR net225 sky130_fd_sc_hd__dlygate4sd3_1
XFILLER_56_410 VGND VGND VPWR VPWR sky130_fd_sc_hd__fill_1
XFILLER_28_145 VGND VGND VPWR VPWR sky130_fd_sc_hd__fill_1
XTAP_TAPCELL_ROW_74_909 VGND VPWR sky130_fd_sc_hd__tapvpwrvgnd_1
XFILLER_83_273 VGND VGND VPWR VPWR sky130_fd_sc_hd__decap_6
XFILLER_16_329 VGND VGND VPWR VPWR sky130_fd_sc_hd__fill_1
XFILLER_45_57 VPWR VGND VPWR VGND sky130_ef_sc_hd__decap_12
XFILLER_12_513 VPWR VGND VPWR VGND sky130_ef_sc_hd__decap_12
XFILLER_6_29 VPWR VGND VPWR VGND sky130_ef_sc_hd__decap_12
XFILLER_10_82 VGND VGND VPWR VPWR sky130_fd_sc_hd__fill_2
XFILLER_10_71 VGND VGND VPWR VPWR sky130_fd_sc_hd__fill_1
XFILLER_10_93 VGND VGND VPWR VPWR sky130_fd_sc_hd__decap_6
XFILLER_47_410 VGND VGND VPWR VPWR sky130_fd_sc_hd__fill_1
XFILLER_59_281 VPWR VGND VPWR VGND sky130_ef_sc_hd__decap_12
XTAP_TAPCELL_ROW_45_633 VGND VPWR sky130_fd_sc_hd__tapvpwrvgnd_1
X_2880_ _0954_ _0961_ VGND VGND VPWR VPWR _1438_ sky130_fd_sc_hd__or2_4
X_1900_ u_parser.u_packet_encoder.tag_latched\[36\] _0896_ _0900_ u_parser.u_packet_encoder.tag_latched\[28\]
+ _0925_ VGND VGND VPWR VPWR _0926_ sky130_fd_sc_hd__a221o_1
X_1831_ u_parser.u_packet_encoder.byte_index\[1\] u_parser.u_packet_encoder.byte_index\[0\]
+ VGND VGND VPWR VPWR _0878_ sky130_fd_sc_hd__nand2b_2
XFILLER_30_365 VPWR VGND VPWR VGND sky130_ef_sc_hd__decap_12
X_1762_ u_uart_tx.clk_count\[13\] _0824_ u_uart_tx.clk_count\[15\] u_uart_tx.clk_count\[14\]
+ VGND VGND VPWR VPWR _0825_ sky130_fd_sc_hd__a211oi_2
X_3501_ clknet_leaf_28_clk _0328_ net136 VGND VGND VPWR VPWR u_parser.u_decoder.timeout_count\[3\]
+ sky130_fd_sc_hd__dfrtp_1
X_1693_ _0754_ _0756_ _0759_ _0671_ VGND VGND VPWR VPWR _0760_ sky130_fd_sc_hd__a22o_1
X_3432_ clknet_leaf_14_clk _0265_ VGND VGND VPWR VPWR u_rx_fifo.mem\[1\]\[0\] sky130_fd_sc_hd__dfxtp_1
X_3363_ clknet_leaf_52_clk _0196_ net93 VGND VGND VPWR VPWR u_parser.u_packet_encoder.crc_latched\[7\]
+ sky130_fd_sc_hd__dfrtp_1
XFILLER_85_505 VPWR VGND VPWR VGND sky130_ef_sc_hd__decap_12
X_3294_ clknet_leaf_1_clk _0130_ VGND VGND VPWR VPWR u_tx_fifo.mem\[5\]\[5\] sky130_fd_sc_hd__dfxtp_1
X_2314_ _1116_ _1117_ net61 VGND VGND VPWR VPWR _1118_ sky130_fd_sc_hd__mux2_1
X_2245_ net244 net33 _1067_ VGND VGND VPWR VPWR _0244_ sky130_fd_sc_hd__mux2_1
X_2176_ _1050_ net553 net55 VGND VGND VPWR VPWR _0192_ sky130_fd_sc_hd__mux2_1
XTAP_TAPCELL_ROW_0_203 VGND VPWR sky130_fd_sc_hd__tapvpwrvgnd_1
XFILLER_25_148 VGND VGND VPWR VPWR sky130_fd_sc_hd__fill_2
Xclkbuf_leaf_60_clk clknet_3_0__leaf_clk VGND VGND VPWR VPWR clknet_leaf_60_clk sky130_fd_sc_hd__clkbuf_8
XFILLER_31_15 VPWR VGND VPWR VGND sky130_ef_sc_hd__decap_12
XPHY_EDGE_ROW_1_Right_1 VGND VGND VPWR VPWR sky130_fd_sc_hd__decap_3
XFILLER_0_225 VPWR VGND VPWR VGND sky130_ef_sc_hd__decap_12
XFILLER_88_365 VGND VGND VPWR VPWR sky130_fd_sc_hd__decap_6
XFILLER_88_398 VGND VGND VPWR VPWR sky130_fd_sc_hd__fill_1
XFILLER_76_527 VGND VGND VPWR VPWR sky130_fd_sc_hd__decap_4
XTAP_TAPCELL_ROW_59_758 VGND VPWR sky130_fd_sc_hd__tapvpwrvgnd_1
XFILLER_44_446 VPWR VGND VPWR VGND sky130_ef_sc_hd__decap_12
XFILLER_56_295 VGND VGND VPWR VPWR sky130_fd_sc_hd__decap_4
XTAP_TAPCELL_ROW_42_603 VGND VPWR sky130_fd_sc_hd__tapvpwrvgnd_1
XFILLER_44_468 VGND VGND VPWR VPWR sky130_fd_sc_hd__decap_4
XFILLER_31_129 VGND VGND VPWR VPWR sky130_fd_sc_hd__fill_2
XTAP_TAPCELL_ROW_14_338 VGND VPWR sky130_fd_sc_hd__tapvpwrvgnd_1
Xclkbuf_leaf_51_clk clknet_3_2__leaf_clk VGND VGND VPWR VPWR clknet_leaf_51_clk sky130_fd_sc_hd__clkbuf_8
XTAP_TAPCELL_ROW_50_680 VGND VPWR sky130_fd_sc_hd__tapvpwrvgnd_1
XFILLER_4_531 VGND VGND VPWR VPWR sky130_fd_sc_hd__fill_1
XFILLER_4_553 VGND VGND VPWR VPWR sky130_fd_sc_hd__fill_2
XFILLER_39_218 VGND VGND VPWR VPWR sky130_fd_sc_hd__decap_6
X_2030_ net232 net29 _0956_ VGND VGND VPWR VPWR _0140_ sky130_fd_sc_hd__mux2_1
XFILLER_50_405 VGND VGND VPWR VPWR sky130_fd_sc_hd__fill_1
X_2932_ u_uart_tx.tx_data\[0\] u_uart_tx.tx_data\[1\] u_uart_tx.tx_data\[2\] u_uart_tx.tx_data\[3\]
+ u_uart_tx.bit_index\[0\] u_uart_tx.bit_index\[1\] VGND VGND VPWR VPWR _1466_ sky130_fd_sc_hd__mux4_1
Xclkbuf_leaf_42_clk clknet_3_3__leaf_clk VGND VGND VPWR VPWR clknet_leaf_42_clk sky130_fd_sc_hd__clkbuf_8
X_2863_ net27 net401 _1436_ VGND VGND VPWR VPWR _0493_ sky130_fd_sc_hd__mux2_1
X_2794_ net479 _0718_ _1409_ VGND VGND VPWR VPWR _0451_ sky130_fd_sc_hd__mux2_1
X_1814_ net569 _0865_ VGND VGND VPWR VPWR _0015_ sky130_fd_sc_hd__xnor2_1
X_1745_ _0675_ u_parser.u_decoder.decoded_checksum_calc\[1\] _0805_ _0806_ _0810_
+ VGND VGND VPWR VPWR _0811_ sky130_fd_sc_hd__o2111a_1
Xhold325 u_uart_rx.low_count\[18\] VGND VGND VPWR VPWR net481 sky130_fd_sc_hd__dlygate4sd3_1
XFILLER_7_391 VGND VGND VPWR VPWR sky130_fd_sc_hd__fill_1
Xhold314 tag_raw\[16\] VGND VGND VPWR VPWR net470 sky130_fd_sc_hd__dlygate4sd3_1
Xhold303 u_parser.u_decoder.decoded_payload\[29\] VGND VGND VPWR VPWR net459 sky130_fd_sc_hd__dlygate4sd3_1
Xhold347 u_parser.u_packet_encoder.tag_latched\[34\] VGND VGND VPWR VPWR net503 sky130_fd_sc_hd__dlygate4sd3_1
Xhold369 tag_raw\[1\] VGND VGND VPWR VPWR net525 sky130_fd_sc_hd__dlygate4sd3_1
Xhold336 u_parser.u_decoder.decoded_payload\[25\] VGND VGND VPWR VPWR net492 sky130_fd_sc_hd__dlygate4sd3_1
Xhold358 u_parser.u_decoder.ascii_buf\[3\]\[7\] VGND VGND VPWR VPWR net514 sky130_fd_sc_hd__dlygate4sd3_1
X_1676_ _0737_ _0739_ _0742_ _0671_ VGND VGND VPWR VPWR _0743_ sky130_fd_sc_hd__a22oi_4
X_3415_ clknet_leaf_5_clk _0248_ VGND VGND VPWR VPWR u_tx_fifo.mem\[2\]\[7\] sky130_fd_sc_hd__dfxtp_1
XTAP_TAPCELL_ROW_90_1053 VGND VPWR sky130_fd_sc_hd__tapvpwrvgnd_1
X_3346_ clknet_leaf_7_clk _0179_ VGND VGND VPWR VPWR u_tx_fifo.mem\[3\]\[6\] sky130_fd_sc_hd__dfxtp_1
XFILLER_85_324 VPWR VGND VPWR VGND sky130_ef_sc_hd__decap_12
X_3277_ clknet_leaf_65_clk _0113_ VGND VGND VPWR VPWR u_tx_fifo.mem\[12\]\[4\] sky130_fd_sc_hd__dfxtp_1
XFILLER_26_15 VPWR VGND VPWR VGND sky130_ef_sc_hd__decap_12
X_2228_ tag_raw\[35\] net507 net56 VGND VGND VPWR VPWR _0232_ sky130_fd_sc_hd__mux2_1
X_2159_ tag_raw\[1\] _1011_ VGND VGND VPWR VPWR _1036_ sky130_fd_sc_hd__xor2_1
XFILLER_81_552 VGND VGND VPWR VPWR sky130_fd_sc_hd__decap_3
XFILLER_41_405 VGND VGND VPWR VPWR sky130_fd_sc_hd__decap_3
Xclkbuf_leaf_33_clk clknet_3_7__leaf_clk VGND VGND VPWR VPWR clknet_leaf_33_clk sky130_fd_sc_hd__clkbuf_8
XTAP_TAPCELL_ROW_11_308 VGND VPWR sky130_fd_sc_hd__tapvpwrvgnd_1
XFILLER_49_516 VPWR VGND VPWR VGND sky130_ef_sc_hd__decap_12
XFILLER_76_379 VGND VGND VPWR VPWR sky130_fd_sc_hd__decap_4
XFILLER_17_413 VGND VGND VPWR VPWR sky130_fd_sc_hd__decap_8
XFILLER_72_530 VGND VGND VPWR VPWR sky130_fd_sc_hd__fill_2
XFILLER_17_457 VGND VGND VPWR VPWR sky130_fd_sc_hd__decap_6
XFILLER_44_287 VGND VGND VPWR VPWR sky130_fd_sc_hd__decap_8
Xclkbuf_leaf_24_clk clknet_3_6__leaf_clk VGND VGND VPWR VPWR clknet_leaf_24_clk sky130_fd_sc_hd__clkbuf_8
X_3200_ clknet_leaf_17_clk _0036_ VGND VGND VPWR VPWR u_rx_fifo.mem\[0\]\[7\] sky130_fd_sc_hd__dfxtp_1
X_3131_ _1520_ _1567_ net473 VGND VGND VPWR VPWR _1569_ sky130_fd_sc_hd__a21oi_1
XFILLER_67_335 VGND VGND VPWR VPWR sky130_fd_sc_hd__fill_1
X_3062_ u_uart_rx.sample_div_count\[2\] u_uart_rx.sample_div_count\[3\] _1522_ VGND
+ VGND VPWR VPWR _1528_ sky130_fd_sc_hd__nand3_1
XFILLER_82_338 VGND VGND VPWR VPWR sky130_fd_sc_hd__fill_2
X_2013_ _0890_ _0954_ VGND VGND VPWR VPWR _0955_ sky130_fd_sc_hd__or2_4
XFILLER_75_390 VGND VGND VPWR VPWR sky130_fd_sc_hd__fill_2
XTAP_TAPCELL_ROW_53_709 VGND VPWR sky130_fd_sc_hd__tapvpwrvgnd_1
XFILLER_63_541 VPWR VGND VPWR VGND sky130_ef_sc_hd__decap_12
XFILLER_23_427 VGND VGND VPWR VPWR sky130_fd_sc_hd__fill_1
XFILLER_35_287 VGND VGND VPWR VPWR sky130_fd_sc_hd__decap_6
XFILLER_50_224 VGND VGND VPWR VPWR sky130_fd_sc_hd__decap_8
Xclkbuf_leaf_15_clk clknet_3_5__leaf_clk VGND VGND VPWR VPWR clknet_leaf_15_clk sky130_fd_sc_hd__clkbuf_8
X_2915_ net625 _1454_ _1441_ VGND VGND VPWR VPWR _1457_ sky130_fd_sc_hd__o21ai_1
X_2846_ net650 _0882_ VGND VGND VPWR VPWR _0485_ sky130_fd_sc_hd__xnor2_1
Xhold100 u_rx_fifo.mem\[8\]\[4\] VGND VGND VPWR VPWR net256 sky130_fd_sc_hd__dlygate4sd3_1
X_2777_ net13 _1402_ _1405_ _1404_ VGND VGND VPWR VPWR _0438_ sky130_fd_sc_hd__a31o_1
Xhold122 u_tx_fifo.mem\[10\]\[1\] VGND VGND VPWR VPWR net278 sky130_fd_sc_hd__dlygate4sd3_1
Xhold133 u_tx_fifo.mem\[11\]\[7\] VGND VGND VPWR VPWR net289 sky130_fd_sc_hd__dlygate4sd3_1
Xhold111 u_tx_fifo.mem\[3\]\[4\] VGND VGND VPWR VPWR net267 sky130_fd_sc_hd__dlygate4sd3_1
Xhold144 u_rx_fifo.mem\[15\]\[5\] VGND VGND VPWR VPWR net300 sky130_fd_sc_hd__dlygate4sd3_1
X_1728_ net42 net36 net35 net38 VGND VGND VPWR VPWR _0795_ sky130_fd_sc_hd__or4b_1
Xhold177 u_rx_fifo.mem\[9\]\[4\] VGND VGND VPWR VPWR net333 sky130_fd_sc_hd__dlygate4sd3_1
Xhold155 u_rx_fifo.mem\[11\]\[2\] VGND VGND VPWR VPWR net311 sky130_fd_sc_hd__dlygate4sd3_1
Xhold166 u_rx_fifo.mem\[13\]\[6\] VGND VGND VPWR VPWR net322 sky130_fd_sc_hd__dlygate4sd3_1
X_1659_ _0721_ _0722_ _0725_ _0671_ VGND VGND VPWR VPWR _0726_ sky130_fd_sc_hd__a22o_1
Xhold188 u_rx_fifo.mem\[6\]\[0\] VGND VGND VPWR VPWR net344 sky130_fd_sc_hd__dlygate4sd3_1
Xhold199 u_tx_fifo.mem\[13\]\[0\] VGND VGND VPWR VPWR net355 sky130_fd_sc_hd__dlygate4sd3_1
XTAP_TAPCELL_ROW_69_853 VGND VPWR sky130_fd_sc_hd__tapvpwrvgnd_1
X_3329_ clknet_leaf_26_clk _0002_ net125 VGND VGND VPWR VPWR u_parser.u_decoder.state\[0\]
+ sky130_fd_sc_hd__dfstp_1
XFILLER_54_530 VGND VGND VPWR VPWR sky130_fd_sc_hd__fill_2
XFILLER_81_371 VPWR VGND VPWR VGND sky130_ef_sc_hd__decap_12
XFILLER_41_202 VGND VGND VPWR VPWR sky130_fd_sc_hd__fill_2
XTAP_TAPCELL_ROW_24_433 VGND VPWR sky130_fd_sc_hd__tapvpwrvgnd_1
XFILLER_53_57 VPWR VGND VPWR VGND sky130_ef_sc_hd__decap_12
XFILLER_89_493 VGND VGND VPWR VPWR sky130_fd_sc_hd__decap_8
XFILLER_76_110 VGND VGND VPWR VPWR sky130_fd_sc_hd__decap_8
XFILLER_76_154 VPWR VGND VPWR VGND sky130_ef_sc_hd__decap_12
XFILLER_37_519 VPWR VGND VPWR VGND sky130_ef_sc_hd__decap_12
XFILLER_91_135 VGND VGND VPWR VPWR sky130_fd_sc_hd__fill_1
XFILLER_17_287 VGND VGND VPWR VPWR sky130_fd_sc_hd__decap_8
XFILLER_60_533 VPWR VGND VPWR VGND sky130_ef_sc_hd__decap_12
XFILLER_13_493 VGND VGND VPWR VPWR sky130_fd_sc_hd__decap_8
X_2700_ u_parser.u_decoder.ascii_buf\[6\]\[2\] net37 _1372_ VGND VGND VPWR VPWR _0394_
+ sky130_fd_sc_hd__mux2_1
X_3680_ clknet_leaf_64_clk _0507_ VGND VGND VPWR VPWR u_tx_fifo.mem\[10\]\[6\] sky130_fd_sc_hd__dfxtp_1
XFILLER_9_497 VGND VGND VPWR VPWR sky130_fd_sc_hd__decap_6
X_2631_ net446 _1320_ net14 VGND VGND VPWR VPWR _0377_ sky130_fd_sc_hd__mux2_1
X_2562_ u_parser.u_decoder.ascii_buf\[4\]\[1\] u_parser.u_decoder.ascii_buf\[4\]\[2\]
+ VGND VGND VPWR VPWR _1265_ sky130_fd_sc_hd__or2_1
XFILLER_57_3 VPWR VGND VPWR VGND sky130_ef_sc_hd__decap_12
X_2493_ u_parser.u_decoder.ascii_buf\[8\]\[3\] u_parser.u_decoder.ascii_buf\[8\]\[4\]
+ u_parser.u_decoder.ascii_buf\[8\]\[7\] u_parser.u_decoder.ascii_buf\[8\]\[6\] VGND
+ VGND VPWR VPWR _1212_ sky130_fd_sc_hd__or4b_1
Xclkbuf_leaf_4_clk clknet_3_1__leaf_clk VGND VGND VPWR VPWR clknet_leaf_4_clk sky130_fd_sc_hd__clkbuf_8
X_3114_ net494 net74 _0845_ VGND VGND VPWR VPWR _0622_ sky130_fd_sc_hd__mux2_1
XFILLER_67_165 VGND VGND VPWR VPWR sky130_fd_sc_hd__decap_3
X_3045_ u_uart_rx.sample_phase\[2\] _0687_ VGND VGND VPWR VPWR _1517_ sky130_fd_sc_hd__nor2_1
XTAP_TAPCELL_ROW_38_558 VGND VPWR sky130_fd_sc_hd__tapvpwrvgnd_1
XTAP_TAPCELL_ROW_21_403 VGND VPWR sky130_fd_sc_hd__tapvpwrvgnd_1
X_2829_ net589 _1415_ VGND VGND VPWR VPWR _0480_ sky130_fd_sc_hd__xor2_1
Xfanout83 rx_fifo_in_data\[1\] VGND VGND VPWR VPWR net83 sky130_fd_sc_hd__buf_2
Xfanout72 rx_fifo_in_data\[6\] VGND VGND VPWR VPWR net72 sky130_fd_sc_hd__buf_2
Xfanout50 _0834_ VGND VGND VPWR VPWR net50 sky130_fd_sc_hd__clkbuf_2
Xfanout61 u_tx_fifo.rd_ptr\[2\] VGND VGND VPWR VPWR net61 sky130_fd_sc_hd__clkbuf_4
XFILLER_80_77 VGND VGND VPWR VPWR sky130_fd_sc_hd__decap_6
Xfanout94 net114 VGND VGND VPWR VPWR net94 sky130_fd_sc_hd__buf_2
XFILLER_13_93 VGND VGND VPWR VPWR sky130_fd_sc_hd__fill_1
XFILLER_6_445 VPWR VGND VPWR VGND sky130_ef_sc_hd__decap_12
XFILLER_6_489 VPWR VGND VPWR VGND sky130_ef_sc_hd__decap_12
XTAP_TAPCELL_ROW_9_283 VGND VPWR sky130_fd_sc_hd__tapvpwrvgnd_1
XFILLER_89_290 VGND VGND VPWR VPWR sky130_fd_sc_hd__decap_6
XFILLER_37_349 VGND VGND VPWR VPWR sky130_fd_sc_hd__fill_1
XFILLER_92_477 VPWR VGND VPWR VGND sky130_ef_sc_hd__decap_12
Xclkbuf_3_7__f_clk clknet_0_clk VGND VGND VPWR VPWR clknet_3_7__leaf_clk sky130_fd_sc_hd__clkbuf_16
XTAP_TAPCELL_ROW_63_804 VGND VPWR sky130_fd_sc_hd__tapvpwrvgnd_1
XFILLER_45_371 VGND VGND VPWR VPWR sky130_fd_sc_hd__fill_1
XFILLER_45_393 VGND VGND VPWR VPWR sky130_fd_sc_hd__fill_2
X_3801_ clknet_leaf_18_clk _0619_ net122 VGND VGND VPWR VPWR rx_fifo_in_data\[2\]
+ sky130_fd_sc_hd__dfrtp_1
X_1993_ u_tx_fifo.wr_ptr\[2\] u_tx_fifo.wr_ptr\[3\] VGND VGND VPWR VPWR _0951_ sky130_fd_sc_hd__nand2_2
XFILLER_20_216 VGND VGND VPWR VPWR sky130_fd_sc_hd__decap_4
X_3732_ clknet_leaf_31_clk _0556_ net142 VGND VGND VPWR VPWR u_uart_rx.low_count\[22\]
+ sky130_fd_sc_hd__dfrtp_1
XFILLER_13_290 VGND VGND VPWR VPWR sky130_fd_sc_hd__decap_3
XFILLER_20_249 VGND VGND VPWR VPWR sky130_fd_sc_hd__decap_3
X_3663_ clknet_leaf_19_clk _0490_ net120 VGND VGND VPWR VPWR u_rx_fifo.rd_ptr\[1\]
+ sky130_fd_sc_hd__dfrtp_2
Xclkload20 clknet_leaf_6_clk VGND VGND VPWR VPWR clkload20/Y sky130_fd_sc_hd__inv_8
X_2614_ net475 _1306_ net9 VGND VGND VPWR VPWR _0374_ sky130_fd_sc_hd__mux2_1
Xclkload31 clknet_leaf_39_clk VGND VGND VPWR VPWR clkload31/Y sky130_fd_sc_hd__clkinvlp_4
Xclkload42 clknet_leaf_12_clk VGND VGND VPWR VPWR clkload42/Y sky130_fd_sc_hd__inv_6
Xclkload53 clknet_leaf_34_clk VGND VGND VPWR VPWR clkload53/Y sky130_fd_sc_hd__inv_6
Xclkload64 clknet_leaf_32_clk VGND VGND VPWR VPWR clkload64/Y sky130_fd_sc_hd__inv_8
X_3594_ clknet_leaf_44_clk _0421_ net112 VGND VGND VPWR VPWR u_parser.u_decoder.ascii_buf\[9\]\[5\]
+ sky130_fd_sc_hd__dfrtp_1
X_2545_ u_parser.u_decoder.ascii_buf\[5\]\[7\] u_parser.u_decoder.ascii_buf\[5\]\[6\]
+ VGND VGND VPWR VPWR _1252_ sky130_fd_sc_hd__nor2_1
X_2476_ u_parser.u_decoder.ascii_buf\[9\]\[0\] u_parser.u_decoder.ascii_buf\[9\]\[3\]
+ _1192_ _1198_ VGND VGND VPWR VPWR _1199_ sky130_fd_sc_hd__o31a_1
XFILLER_28_305 VGND VGND VPWR VPWR sky130_fd_sc_hd__decap_3
XFILLER_68_474 VGND VGND VPWR VPWR sky130_fd_sc_hd__fill_2
XTAP_TAPCELL_ROW_87_1025 VGND VPWR sky130_fd_sc_hd__tapvpwrvgnd_1
XFILLER_55_113 VGND VGND VPWR VPWR sky130_fd_sc_hd__decap_4
X_3028_ net413 net80 _1507_ VGND VGND VPWR VPWR _0587_ sky130_fd_sc_hd__mux2_1
XFILLER_24_511 VGND VGND VPWR VPWR sky130_fd_sc_hd__fill_1
XFILLER_24_533 VPWR VGND VPWR VGND sky130_ef_sc_hd__decap_12
XFILLER_34_15 VPWR VGND VPWR VGND sky130_ef_sc_hd__decap_12
Xclkload3 clknet_3_4__leaf_clk VGND VGND VPWR VPWR clkload3/Y sky130_fd_sc_hd__inv_6
XTAP_TAPCELL_ROW_77_929 VGND VPWR sky130_fd_sc_hd__tapvpwrvgnd_1
XFILLER_75_55 VGND VGND VPWR VPWR sky130_fd_sc_hd__fill_1
XFILLER_74_455 VPWR VGND VPWR VGND sky130_ef_sc_hd__decap_12
XFILLER_75_66 VGND VGND VPWR VPWR sky130_fd_sc_hd__decap_3
XFILLER_27_371 VGND VGND VPWR VPWR sky130_fd_sc_hd__decap_3
XFILLER_15_522 VPWR VGND VPWR VGND sky130_ef_sc_hd__decap_12
XTAP_TAPCELL_ROW_32_509 VGND VPWR sky130_fd_sc_hd__tapvpwrvgnd_1
XTAP_TAPCELL_ROW_40_586 VGND VPWR sky130_fd_sc_hd__tapvpwrvgnd_1
XFILLER_6_253 VPWR VGND VPWR VGND sky130_ef_sc_hd__decap_12
XFILLER_6_275 VGND VGND VPWR VPWR sky130_fd_sc_hd__fill_1
X_2330_ _0868_ _0887_ VGND VGND VPWR VPWR _1132_ sky130_fd_sc_hd__or2_4
X_2261_ u_tx_fifo.mem\[8\]\[0\] u_tx_fifo.mem\[9\]\[0\] u_tx_fifo.mem\[10\]\[0\] u_tx_fifo.mem\[11\]\[0\]
+ net67 net63 VGND VGND VPWR VPWR _1071_ sky130_fd_sc_hd__mux4_1
X_2192_ _1062_ net543 net52 VGND VGND VPWR VPWR _0196_ sky130_fd_sc_hd__mux2_1
XFILLER_65_433 VGND VGND VPWR VPWR sky130_fd_sc_hd__decap_4
XFILLER_1_63 VGND VGND VPWR VPWR sky130_fd_sc_hd__fill_1
XTAP_TAPCELL_ROW_48_653 VGND VPWR sky130_fd_sc_hd__tapvpwrvgnd_1
XFILLER_18_360 VGND VGND VPWR VPWR sky130_fd_sc_hd__decap_4
XFILLER_18_393 VGND VGND VPWR VPWR sky130_fd_sc_hd__fill_2
XFILLER_21_503 VGND VGND VPWR VPWR sky130_fd_sc_hd__fill_1
XFILLER_33_363 VGND VGND VPWR VPWR sky130_fd_sc_hd__decap_3
X_1976_ net82 net396 _0948_ VGND VGND VPWR VPWR _0094_ sky130_fd_sc_hd__mux2_1
X_3715_ clknet_leaf_33_clk _0539_ net141 VGND VGND VPWR VPWR u_uart_rx.low_count\[5\]
+ sky130_fd_sc_hd__dfrtp_1
X_3646_ clknet_leaf_7_clk _0473_ net96 VGND VGND VPWR VPWR u_parser.u_decoder.ascii_buf\[4\]\[1\]
+ sky130_fd_sc_hd__dfrtp_1
X_3577_ clknet_leaf_25_clk _0404_ net129 VGND VGND VPWR VPWR u_parser.u_decoder.ascii_buf\[10\]\[4\]
+ sky130_fd_sc_hd__dfrtp_1
XTAP_TAPCELL_ROW_93_1084 VGND VPWR sky130_fd_sc_hd__tapvpwrvgnd_1
X_2528_ u_parser.u_decoder.ascii_buf\[6\]\[4\] u_parser.u_decoder.ascii_buf\[6\]\[5\]
+ _1237_ _1238_ VGND VGND VPWR VPWR _1239_ sky130_fd_sc_hd__and4_1
XTAP_TAPCELL_ROW_93_1095 VGND VPWR sky130_fd_sc_hd__tapvpwrvgnd_1
XFILLER_29_15 VGND VGND VPWR VPWR sky130_fd_sc_hd__decap_8
Xhold26 u_tx_fifo.mem\[8\]\[6\] VGND VGND VPWR VPWR net182 sky130_fd_sc_hd__dlygate4sd3_1
Xhold37 u_tx_fifo.mem\[12\]\[2\] VGND VGND VPWR VPWR net193 sky130_fd_sc_hd__dlygate4sd3_1
Xhold15 u_tx_fifo.mem\[2\]\[5\] VGND VGND VPWR VPWR net171 sky130_fd_sc_hd__dlygate4sd3_1
X_2459_ u_parser.u_decoder.timeout_count\[15\] _1184_ net3 VGND VGND VPWR VPWR _1186_
+ sky130_fd_sc_hd__a21boi_1
XTAP_TAPCELL_ROW_3_234 VGND VPWR sky130_fd_sc_hd__tapvpwrvgnd_1
Xhold59 u_tx_fifo.mem\[2\]\[4\] VGND VGND VPWR VPWR net215 sky130_fd_sc_hd__dlygate4sd3_1
Xhold48 u_tx_fifo.mem\[4\]\[4\] VGND VGND VPWR VPWR net204 sky130_fd_sc_hd__dlygate4sd3_1
XFILLER_71_403 VGND VGND VPWR VPWR sky130_fd_sc_hd__fill_1
XFILLER_83_296 VGND VGND VPWR VPWR sky130_fd_sc_hd__fill_1
XFILLER_45_69 VPWR VGND VPWR VGND sky130_ef_sc_hd__decap_12
XFILLER_71_447 VGND VGND VPWR VPWR sky130_fd_sc_hd__fill_1
XTAP_TAPCELL_ROW_82_976 VGND VPWR sky130_fd_sc_hd__tapvpwrvgnd_1
XFILLER_24_363 VGND VGND VPWR VPWR sky130_fd_sc_hd__fill_1
XFILLER_12_525 VGND VGND VPWR VPWR sky130_fd_sc_hd__decap_6
XFILLER_61_57 VGND VGND VPWR VPWR sky130_fd_sc_hd__decap_4
XFILLER_59_293 VGND VGND VPWR VPWR sky130_fd_sc_hd__fill_1
XFILLER_62_469 VGND VGND VPWR VPWR sky130_fd_sc_hd__fill_2
XFILLER_42_171 VGND VGND VPWR VPWR sky130_fd_sc_hd__decap_6
X_1830_ _0876_ _0877_ VGND VGND VPWR VPWR _0019_ sky130_fd_sc_hd__and2_1
XFILLER_30_377 VGND VGND VPWR VPWR sky130_fd_sc_hd__decap_6
X_3500_ clknet_leaf_26_clk _0327_ net122 VGND VGND VPWR VPWR u_parser.u_decoder.timeout_count\[2\]
+ sky130_fd_sc_hd__dfrtp_1
X_1761_ u_uart_tx.clk_count\[11\] _0823_ u_uart_tx.clk_count\[12\] VGND VGND VPWR
+ VPWR _0824_ sky130_fd_sc_hd__a21o_1
X_1692_ _0757_ _0758_ net58 VGND VGND VPWR VPWR _0759_ sky130_fd_sc_hd__mux2_1
X_3431_ clknet_leaf_61_clk _0264_ net88 VGND VGND VPWR VPWR u_uart_tx.tx_data\[7\]
+ sky130_fd_sc_hd__dfrtp_1
X_3362_ clknet_leaf_52_clk _0195_ net94 VGND VGND VPWR VPWR u_parser.u_packet_encoder.crc_latched\[6\]
+ sky130_fd_sc_hd__dfrtp_1
X_2313_ u_tx_fifo.mem\[4\]\[6\] u_tx_fifo.mem\[5\]\[6\] u_tx_fifo.mem\[6\]\[6\] u_tx_fifo.mem\[7\]\[6\]
+ net68 net64 VGND VGND VPWR VPWR _1117_ sky130_fd_sc_hd__mux4_1
XFILLER_85_517 VPWR VGND VPWR VGND sky130_ef_sc_hd__decap_12
X_3293_ clknet_leaf_1_clk _0129_ VGND VGND VPWR VPWR u_tx_fifo.mem\[5\]\[4\] sky130_fd_sc_hd__dfxtp_1
X_2244_ net356 net24 _1067_ VGND VGND VPWR VPWR _0243_ sky130_fd_sc_hd__mux2_1
X_2175_ _1043_ _1049_ VGND VGND VPWR VPWR _1050_ sky130_fd_sc_hd__xnor2_1
XTAP_TAPCELL_ROW_0_204 VGND VPWR sky130_fd_sc_hd__tapvpwrvgnd_1
XPHY_EDGE_ROW_69_Left_163 VGND VGND VPWR VPWR sky130_fd_sc_hd__decap_3
XFILLER_38_499 VGND VGND VPWR VPWR sky130_fd_sc_hd__fill_2
XPHY_EDGE_ROW_78_Left_172 VGND VGND VPWR VPWR sky130_fd_sc_hd__decap_3
X_1959_ net180 net79 _0945_ VGND VGND VPWR VPWR _0080_ sky130_fd_sc_hd__mux2_1
X_3629_ clknet_leaf_22_clk _0456_ net118 VGND VGND VPWR VPWR u_parser.u_decoder.ascii_buf\[2\]\[0\]
+ sky130_fd_sc_hd__dfrtp_1
XFILLER_0_237 VPWR VGND VPWR VGND sky130_ef_sc_hd__decap_12
XPHY_EDGE_ROW_87_Left_181 VGND VGND VPWR VPWR sky130_fd_sc_hd__decap_3
XTAP_TAPCELL_ROW_59_759 VGND VPWR sky130_fd_sc_hd__tapvpwrvgnd_1
XTAP_TAPCELL_ROW_42_604 VGND VPWR sky130_fd_sc_hd__tapvpwrvgnd_1
XFILLER_44_458 VGND VGND VPWR VPWR sky130_fd_sc_hd__fill_1
XTAP_TAPCELL_ROW_14_339 VGND VPWR sky130_fd_sc_hd__tapvpwrvgnd_1
XFILLER_8_359 VGND VGND VPWR VPWR sky130_fd_sc_hd__decap_4
XTAP_TAPCELL_ROW_50_681 VGND VPWR sky130_fd_sc_hd__tapvpwrvgnd_1
XFILLER_90_531 VGND VGND VPWR VPWR sky130_fd_sc_hd__fill_1
XFILLER_35_447 VGND VGND VPWR VPWR sky130_fd_sc_hd__fill_1
XFILLER_90_553 VGND VGND VPWR VPWR sky130_fd_sc_hd__fill_2
X_2931_ u_uart_tx.state\[2\] net576 VGND VGND VPWR VPWR _0532_ sky130_fd_sc_hd__and2_1
XFILLER_22_108 VGND VGND VPWR VPWR sky130_fd_sc_hd__decap_6
XFILLER_50_417 VGND VGND VPWR VPWR sky130_fd_sc_hd__decap_3
Xclkbuf_0_clk clk VGND VGND VPWR VPWR clknet_0_clk sky130_fd_sc_hd__clkbuf_16
XFILLER_87_3 VPWR VGND VPWR VGND sky130_ef_sc_hd__decap_12
X_2862_ _0954_ _1435_ VGND VGND VPWR VPWR _1436_ sky130_fd_sc_hd__or2_4
XFILLER_30_174 VGND VGND VPWR VPWR sky130_fd_sc_hd__decap_6
X_2793_ u_parser.u_decoder.ascii_buf\[1\]\[2\] net37 _1409_ VGND VGND VPWR VPWR _0450_
+ sky130_fd_sc_hd__mux2_1
X_1813_ _0863_ _0864_ _0852_ VGND VGND VPWR VPWR _0865_ sky130_fd_sc_hd__o21ai_1
XFILLER_7_73 VGND VGND VPWR VPWR sky130_fd_sc_hd__decap_4
X_1744_ u_parser.u_decoder.decoded_checksum_rx\[4\] _0680_ _0807_ _0808_ _0809_ VGND
+ VGND VPWR VPWR _0810_ sky130_fd_sc_hd__o2111a_1
Xhold304 u_parser.u_decoder.timeout_count\[1\] VGND VGND VPWR VPWR net460 sky130_fd_sc_hd__dlygate4sd3_1
Xhold315 u_parser.u_decoder.decoded_payload\[26\] VGND VGND VPWR VPWR net471 sky130_fd_sc_hd__dlygate4sd3_1
Xhold326 u_parser.u_decoder.ascii_buf\[2\]\[7\] VGND VGND VPWR VPWR net482 sky130_fd_sc_hd__dlygate4sd3_1
X_1675_ _0740_ _0741_ net58 VGND VGND VPWR VPWR _0742_ sky130_fd_sc_hd__mux2_2
Xhold348 u_parser.u_packet_encoder.tag_latched\[39\] VGND VGND VPWR VPWR net504 sky130_fd_sc_hd__dlygate4sd3_1
Xhold359 u_parser.u_packet_encoder.tag_latched\[16\] VGND VGND VPWR VPWR net515 sky130_fd_sc_hd__dlygate4sd3_1
X_3414_ clknet_leaf_7_clk _0247_ VGND VGND VPWR VPWR u_tx_fifo.mem\[2\]\[6\] sky130_fd_sc_hd__dfxtp_1
Xhold337 u_parser.u_decoder.ascii_buf\[6\]\[7\] VGND VGND VPWR VPWR net493 sky130_fd_sc_hd__dlygate4sd3_1
XPHY_EDGE_ROW_15_Right_15 VGND VGND VPWR VPWR sky130_fd_sc_hd__decap_3
XTAP_TAPCELL_ROW_90_1054 VGND VPWR sky130_fd_sc_hd__tapvpwrvgnd_1
X_3345_ clknet_leaf_58_clk _0178_ VGND VGND VPWR VPWR u_tx_fifo.mem\[3\]\[5\] sky130_fd_sc_hd__dfxtp_1
X_3276_ clknet_leaf_62_clk _0112_ VGND VGND VPWR VPWR u_tx_fifo.mem\[12\]\[3\] sky130_fd_sc_hd__dfxtp_1
X_2227_ tag_raw\[34\] net503 net51 VGND VGND VPWR VPWR _0231_ sky130_fd_sc_hd__mux2_1
XTAP_TAPCELL_ROW_56_729 VGND VPWR sky130_fd_sc_hd__tapvpwrvgnd_1
X_2158_ _1018_ _1034_ VGND VGND VPWR VPWR _1035_ sky130_fd_sc_hd__xnor2_1
XFILLER_26_27 VGND VGND VPWR VPWR sky130_fd_sc_hd__fill_1
XFILLER_26_38 VPWR VGND VPWR VGND sky130_ef_sc_hd__decap_12
XFILLER_38_296 VGND VGND VPWR VPWR sky130_fd_sc_hd__fill_1
XPHY_EDGE_ROW_24_Right_24 VGND VGND VPWR VPWR sky130_fd_sc_hd__decap_3
X_2089_ net611 _0967_ VGND VGND VPWR VPWR _0188_ sky130_fd_sc_hd__and2_1
XFILLER_53_277 VGND VGND VPWR VPWR sky130_fd_sc_hd__decap_3
XFILLER_42_15 VPWR VGND VPWR VGND sky130_ef_sc_hd__decap_12
XTAP_TAPCELL_ROW_11_309 VGND VPWR sky130_fd_sc_hd__tapvpwrvgnd_1
XPHY_EDGE_ROW_33_Right_33 VGND VGND VPWR VPWR sky130_fd_sc_hd__decap_3
XFILLER_88_141 VGND VGND VPWR VPWR sky130_fd_sc_hd__decap_3
XFILLER_49_528 VPWR VGND VPWR VGND sky130_ef_sc_hd__decap_12
XFILLER_76_336 VGND VGND VPWR VPWR sky130_fd_sc_hd__fill_1
XFILLER_84_380 VGND VGND VPWR VPWR sky130_fd_sc_hd__decap_8
XPHY_EDGE_ROW_42_Right_42 VGND VGND VPWR VPWR sky130_fd_sc_hd__decap_3
XFILLER_83_55 VGND VGND VPWR VPWR sky130_fd_sc_hd__fill_1
XFILLER_72_553 VGND VGND VPWR VPWR sky130_fd_sc_hd__fill_2
XFILLER_12_163 VGND VGND VPWR VPWR sky130_fd_sc_hd__decap_8
XFILLER_40_494 VPWR VGND VPWR VGND sky130_ef_sc_hd__decap_12
XPHY_EDGE_ROW_51_Right_51 VGND VGND VPWR VPWR sky130_fd_sc_hd__decap_3
X_3130_ u_uart_rx.vote_ones\[0\] _1567_ VGND VGND VPWR VPWR _1568_ sky130_fd_sc_hd__and2_1
X_3061_ u_uart_rx.sample_div_count\[2\] _1522_ u_uart_rx.sample_div_count\[3\] VGND
+ VGND VPWR VPWR _1527_ sky130_fd_sc_hd__a21o_1
XFILLER_48_550 VGND VGND VPWR VPWR sky130_fd_sc_hd__decap_4
XPHY_EDGE_ROW_60_Right_60 VGND VGND VPWR VPWR sky130_fd_sc_hd__decap_3
X_2012_ u_tx_fifo.wr_ptr\[1\] _0882_ u_tx_fifo.wr_ptr\[0\] VGND VGND VPWR VPWR _0954_
+ sky130_fd_sc_hd__or3b_2
XFILLER_35_233 VGND VGND VPWR VPWR sky130_fd_sc_hd__fill_1
XFILLER_63_553 VGND VGND VPWR VPWR sky130_fd_sc_hd__fill_2
XFILLER_50_203 VGND VGND VPWR VPWR sky130_fd_sc_hd__fill_1
X_2914_ u_uart_tx.clk_count\[8\] u_uart_tx.clk_count\[7\] _1452_ VGND VGND VPWR VPWR
+ _1456_ sky130_fd_sc_hd__and3_1
X_2845_ net600 _1427_ VGND VGND VPWR VPWR _0484_ sky130_fd_sc_hd__xnor2_1
XFILLER_31_494 VGND VGND VPWR VPWR sky130_fd_sc_hd__fill_1
Xhold101 u_rx_fifo.mem\[4\]\[6\] VGND VGND VPWR VPWR net257 sky130_fd_sc_hd__dlygate4sd3_1
X_2776_ u_parser.u_decoder.ascii_buf\[10\]\[0\] u_parser.u_decoder.ascii_buf\[10\]\[1\]
+ _1398_ u_parser.u_decoder.ascii_buf\[10\]\[2\] VGND VGND VPWR VPWR _1405_ sky130_fd_sc_hd__a31o_1
Xhold112 u_tx_fifo.mem\[11\]\[5\] VGND VGND VPWR VPWR net268 sky130_fd_sc_hd__dlygate4sd3_1
Xhold134 u_tx_fifo.mem\[3\]\[3\] VGND VGND VPWR VPWR net290 sky130_fd_sc_hd__dlygate4sd3_1
Xhold123 u_tx_fifo.mem\[5\]\[1\] VGND VGND VPWR VPWR net279 sky130_fd_sc_hd__dlygate4sd3_1
X_1727_ _0793_ VGND VGND VPWR VPWR _0794_ sky130_fd_sc_hd__inv_2
Xhold145 u_tx_fifo.mem\[3\]\[1\] VGND VGND VPWR VPWR net301 sky130_fd_sc_hd__dlygate4sd3_1
Xhold167 u_rx_fifo.mem\[8\]\[7\] VGND VGND VPWR VPWR net323 sky130_fd_sc_hd__dlygate4sd3_1
Xhold156 u_rx_fifo.mem\[11\]\[7\] VGND VGND VPWR VPWR net312 sky130_fd_sc_hd__dlygate4sd3_1
X_1658_ _0723_ _0724_ net146 VGND VGND VPWR VPWR _0725_ sky130_fd_sc_hd__mux2_1
Xhold178 u_rx_fifo.mem\[4\]\[4\] VGND VGND VPWR VPWR net334 sky130_fd_sc_hd__dlygate4sd3_1
Xhold189 u_rx_fifo.mem\[10\]\[2\] VGND VGND VPWR VPWR net345 sky130_fd_sc_hd__dlygate4sd3_1
X_3328_ clknet_leaf_19_clk _0164_ VGND VGND VPWR VPWR u_rx_fifo.mem\[12\]\[7\] sky130_fd_sc_hd__dfxtp_1
X_1589_ u_rx_fifo.level\[2\] VGND VGND VPWR VPWR _0659_ sky130_fd_sc_hd__inv_2
XFILLER_37_15 VPWR VGND VPWR VGND sky130_ef_sc_hd__decap_12
XFILLER_58_347 VGND VGND VPWR VPWR sky130_fd_sc_hd__fill_1
XTAP_TAPCELL_ROW_69_854 VGND VPWR sky130_fd_sc_hd__tapvpwrvgnd_1
X_3259_ clknet_leaf_13_clk _0095_ VGND VGND VPWR VPWR u_rx_fifo.mem\[3\]\[2\] sky130_fd_sc_hd__dfxtp_1
XFILLER_26_222 VGND VGND VPWR VPWR sky130_fd_sc_hd__fill_1
XFILLER_81_383 VGND VGND VPWR VPWR sky130_fd_sc_hd__fill_2
XFILLER_14_417 VGND VGND VPWR VPWR sky130_fd_sc_hd__decap_3
XTAP_TAPCELL_ROW_24_434 VGND VPWR sky130_fd_sc_hd__tapvpwrvgnd_1
XFILLER_53_69 VGND VGND VPWR VPWR sky130_fd_sc_hd__decap_8
XFILLER_22_472 VGND VGND VPWR VPWR sky130_fd_sc_hd__decap_4
XFILLER_22_494 VGND VGND VPWR VPWR sky130_fd_sc_hd__fill_1
XFILLER_1_321 VGND VGND VPWR VPWR sky130_fd_sc_hd__fill_1
XFILLER_76_166 VGND VGND VPWR VPWR sky130_fd_sc_hd__fill_1
XFILLER_91_169 VGND VGND VPWR VPWR sky130_fd_sc_hd__fill_2
XFILLER_45_553 VGND VGND VPWR VPWR sky130_fd_sc_hd__fill_2
XFILLER_60_545 VGND VGND VPWR VPWR sky130_fd_sc_hd__decap_8
X_2630_ _1318_ _1319_ VGND VGND VPWR VPWR _1320_ sky130_fd_sc_hd__and2_1
X_2561_ net454 _1264_ net11 VGND VGND VPWR VPWR _0363_ sky130_fd_sc_hd__mux2_1
X_2492_ u_parser.u_decoder.ascii_buf\[8\]\[0\] _1210_ VGND VGND VPWR VPWR _1211_ sky130_fd_sc_hd__nand2_1
XFILLER_4_74 VGND VGND VPWR VPWR sky130_fd_sc_hd__fill_1
XFILLER_4_85 VGND VGND VPWR VPWR sky130_fd_sc_hd__decap_3
X_3113_ net498 net76 _0845_ VGND VGND VPWR VPWR _0621_ sky130_fd_sc_hd__mux2_1
X_3044_ _1515_ _1516_ VGND VGND VPWR VPWR _0594_ sky130_fd_sc_hd__and2_1
XTAP_TAPCELL_ROW_66_824 VGND VPWR sky130_fd_sc_hd__tapvpwrvgnd_1
XFILLER_82_158 VGND VGND VPWR VPWR sky130_fd_sc_hd__fill_1
XFILLER_82_136 VGND VGND VPWR VPWR sky130_fd_sc_hd__decap_4
XFILLER_36_553 VGND VGND VPWR VPWR sky130_fd_sc_hd__fill_2
XTAP_TAPCELL_ROW_38_559 VGND VPWR sky130_fd_sc_hd__tapvpwrvgnd_1
XFILLER_51_501 VGND VGND VPWR VPWR sky130_fd_sc_hd__decap_3
XFILLER_23_225 VGND VGND VPWR VPWR sky130_fd_sc_hd__decap_6
XTAP_TAPCELL_ROW_21_404 VGND VPWR sky130_fd_sc_hd__tapvpwrvgnd_1
X_2828_ _1413_ _1414_ VGND VGND VPWR VPWR _1415_ sky130_fd_sc_hd__or2_1
X_2759_ u_parser.u_decoder.ascii_buf\[11\]\[3\] _1382_ _1379_ VGND VGND VPWR VPWR
+ _1391_ sky130_fd_sc_hd__a21o_1
XFILLER_61_309 VGND VGND VPWR VPWR sky130_fd_sc_hd__decap_4
XPHY_EDGE_ROW_14_Left_108 VGND VGND VPWR VPWR sky130_fd_sc_hd__decap_3
XFILLER_14_258 VGND VGND VPWR VPWR sky130_fd_sc_hd__fill_1
Xfanout40 _0752_ VGND VGND VPWR VPWR net40 sky130_fd_sc_hd__clkbuf_4
Xfanout73 rx_fifo_in_data\[6\] VGND VGND VPWR VPWR net73 sky130_fd_sc_hd__clkbuf_2
XFILLER_80_56 VGND VGND VPWR VPWR sky130_fd_sc_hd__decap_4
Xfanout51 net57 VGND VGND VPWR VPWR net51 sky130_fd_sc_hd__clkbuf_4
Xfanout62 u_tx_fifo.rd_ptr\[1\] VGND VGND VPWR VPWR net62 sky130_fd_sc_hd__clkbuf_4
Xfanout84 net85 VGND VGND VPWR VPWR net84 sky130_fd_sc_hd__clkbuf_2
XFILLER_22_280 VGND VGND VPWR VPWR sky130_fd_sc_hd__fill_1
Xfanout95 net101 VGND VGND VPWR VPWR net95 sky130_fd_sc_hd__clkbuf_4
XFILLER_10_475 VGND VGND VPWR VPWR sky130_fd_sc_hd__fill_1
XFILLER_6_457 VPWR VGND VPWR VGND sky130_ef_sc_hd__decap_12
XPHY_EDGE_ROW_23_Left_117 VGND VGND VPWR VPWR sky130_fd_sc_hd__decap_3
XTAP_TAPCELL_ROW_9_284 VGND VPWR sky130_fd_sc_hd__tapvpwrvgnd_1
XFILLER_77_431 VGND VGND VPWR VPWR sky130_fd_sc_hd__fill_1
XFILLER_49_111 VGND VGND VPWR VPWR sky130_fd_sc_hd__fill_1
XFILLER_18_531 VGND VGND VPWR VPWR sky130_fd_sc_hd__fill_1
XFILLER_18_553 VGND VGND VPWR VPWR sky130_fd_sc_hd__fill_2
XPHY_EDGE_ROW_32_Left_126 VGND VGND VPWR VPWR sky130_fd_sc_hd__decap_3
XFILLER_92_489 VPWR VGND VPWR VGND sky130_ef_sc_hd__decap_12
XFILLER_33_523 VPWR VGND VPWR VGND sky130_ef_sc_hd__decap_12
X_3800_ clknet_leaf_17_clk _0618_ net121 VGND VGND VPWR VPWR rx_fifo_in_data\[1\]
+ sky130_fd_sc_hd__dfrtp_1
X_3731_ clknet_leaf_31_clk _0555_ net142 VGND VGND VPWR VPWR u_uart_rx.low_count\[21\]
+ sky130_fd_sc_hd__dfrtp_1
X_1992_ u_tx_fifo.wr_ptr\[0\] u_tx_fifo.wr_ptr\[1\] _0882_ VGND VGND VPWR VPWR _0950_
+ sky130_fd_sc_hd__or3_4
X_3662_ clknet_leaf_19_clk _0489_ net120 VGND VGND VPWR VPWR u_rx_fifo.rd_ptr\[0\]
+ sky130_fd_sc_hd__dfrtp_2
Xclkload10 clknet_leaf_61_clk VGND VGND VPWR VPWR clkload10/Y sky130_fd_sc_hd__clkinv_4
XPHY_EDGE_ROW_41_Left_135 VGND VGND VPWR VPWR sky130_fd_sc_hd__decap_3
Xclkload21 clknet_leaf_7_clk VGND VGND VPWR VPWR clkload21/X sky130_fd_sc_hd__clkbuf_4
Xclkload32 clknet_leaf_40_clk VGND VGND VPWR VPWR clkload32/Y sky130_fd_sc_hd__clkinvlp_4
X_3593_ clknet_leaf_35_clk _0420_ net132 VGND VGND VPWR VPWR u_parser.u_decoder.ascii_buf\[9\]\[4\]
+ sky130_fd_sc_hd__dfrtp_1
Xclkload43 clknet_leaf_22_clk VGND VGND VPWR VPWR clkload43/Y sky130_fd_sc_hd__clkinv_8
X_2613_ u_parser.u_decoder.ascii_buf\[2\]\[2\] _1302_ _1301_ VGND VGND VPWR VPWR _1306_
+ sky130_fd_sc_hd__o21a_1
X_2544_ u_parser.u_decoder.ascii_buf\[5\]\[1\] u_parser.u_decoder.ascii_buf\[5\]\[2\]
+ u_parser.u_decoder.ascii_buf\[5\]\[3\] VGND VGND VPWR VPWR _1251_ sky130_fd_sc_hd__o21ai_1
Xclkload54 clknet_leaf_35_clk VGND VGND VPWR VPWR clkload54/Y sky130_fd_sc_hd__bufinv_16
X_2475_ u_parser.u_decoder.ascii_buf\[9\]\[0\] u_parser.u_decoder.ascii_buf\[9\]\[1\]
+ u_parser.u_decoder.ascii_buf\[9\]\[2\] _1197_ VGND VGND VPWR VPWR _1198_ sky130_fd_sc_hd__a31oi_1
XPHY_EDGE_ROW_50_Left_144 VGND VGND VPWR VPWR sky130_fd_sc_hd__decap_3
XTAP_TAPCELL_ROW_87_1026 VGND VPWR sky130_fd_sc_hd__tapvpwrvgnd_1
XFILLER_83_445 VGND VGND VPWR VPWR sky130_fd_sc_hd__decap_3
X_3027_ net372 net82 _1507_ VGND VGND VPWR VPWR _0586_ sky130_fd_sc_hd__mux2_1
XFILLER_24_545 VGND VGND VPWR VPWR sky130_fd_sc_hd__decap_8
XFILLER_34_27 VGND VGND VPWR VPWR sky130_fd_sc_hd__fill_1
XFILLER_70_139 VGND VGND VPWR VPWR sky130_fd_sc_hd__fill_1
Xclkload4 clknet_3_5__leaf_clk VGND VGND VPWR VPWR clkload4/Y sky130_fd_sc_hd__clkinvlp_4
XFILLER_50_15 VPWR VGND VPWR VGND sky130_ef_sc_hd__decap_12
XFILLER_3_405 VPWR VGND VPWR VGND sky130_ef_sc_hd__decap_12
XFILLER_3_449 VPWR VGND VPWR VGND sky130_ef_sc_hd__decap_12
XFILLER_78_217 VGND VGND VPWR VPWR sky130_fd_sc_hd__fill_1
XFILLER_59_57 VGND VGND VPWR VPWR sky130_fd_sc_hd__decap_6
XFILLER_59_420 VGND VGND VPWR VPWR sky130_fd_sc_hd__decap_6
XFILLER_93_209 VPWR VGND VPWR VGND sky130_ef_sc_hd__decap_12
XTAP_TAPCELL_ROW_6_254 VGND VPWR sky130_fd_sc_hd__tapvpwrvgnd_1
XFILLER_46_147 VGND VGND VPWR VPWR sky130_fd_sc_hd__fill_1
XFILLER_74_467 VGND VGND VPWR VPWR sky130_fd_sc_hd__decap_6
XFILLER_15_534 VPWR VGND VPWR VGND sky130_ef_sc_hd__decap_12
XFILLER_91_55 VGND VGND VPWR VPWR sky130_fd_sc_hd__fill_1
XFILLER_6_265 VGND VGND VPWR VPWR sky130_fd_sc_hd__decap_4
XFILLER_40_70 VPWR VGND VPWR VGND sky130_ef_sc_hd__decap_12
X_2260_ _1068_ _1069_ net61 VGND VGND VPWR VPWR _1070_ sky130_fd_sc_hd__mux2_1
XFILLER_77_250 VPWR VGND VPWR VGND sky130_ef_sc_hd__decap_12
X_2191_ _1011_ _1060_ VGND VGND VPWR VPWR _1062_ sky130_fd_sc_hd__xor2_1
XFILLER_92_253 VGND VGND VPWR VPWR sky130_fd_sc_hd__decap_8
XFILLER_80_415 VGND VGND VPWR VPWR sky130_fd_sc_hd__decap_4
XTAP_TAPCELL_ROW_48_654 VGND VPWR sky130_fd_sc_hd__tapvpwrvgnd_1
XFILLER_65_478 VGND VGND VPWR VPWR sky130_fd_sc_hd__decap_3
XFILLER_80_448 VGND VGND VPWR VPWR sky130_fd_sc_hd__fill_1
XFILLER_33_331 VGND VGND VPWR VPWR sky130_fd_sc_hd__decap_4
XFILLER_33_386 VGND VGND VPWR VPWR sky130_fd_sc_hd__fill_1
X_1975_ net84 net403 _0948_ VGND VGND VPWR VPWR _0093_ sky130_fd_sc_hd__mux2_1
XFILLER_60_194 VGND VGND VPWR VPWR sky130_fd_sc_hd__fill_2
X_3714_ clknet_leaf_32_clk _0538_ net141 VGND VGND VPWR VPWR u_uart_rx.low_count\[4\]
+ sky130_fd_sc_hd__dfrtp_1
X_3645_ clknet_leaf_7_clk _0472_ net96 VGND VGND VPWR VPWR u_parser.u_decoder.ascii_buf\[4\]\[0\]
+ sky130_fd_sc_hd__dfrtp_1
X_3576_ clknet_leaf_25_clk _0403_ net128 VGND VGND VPWR VPWR u_parser.u_decoder.ascii_buf\[10\]\[3\]
+ sky130_fd_sc_hd__dfrtp_1
XTAP_TAPCELL_ROW_93_1085 VGND VPWR sky130_fd_sc_hd__tapvpwrvgnd_1
X_2527_ u_parser.u_decoder.ascii_buf\[6\]\[7\] u_parser.u_decoder.ascii_buf\[6\]\[6\]
+ VGND VGND VPWR VPWR _1238_ sky130_fd_sc_hd__nor2_1
XTAP_TAPCELL_ROW_93_1096 VGND VPWR sky130_fd_sc_hd__tapvpwrvgnd_1
X_2458_ net4 _1183_ _1185_ VGND VGND VPWR VPWR _0339_ sky130_fd_sc_hd__and3_1
XPHY_EDGE_ROW_89_Right_89 VGND VGND VPWR VPWR sky130_fd_sc_hd__decap_3
Xhold16 u_tx_fifo.mem\[8\]\[4\] VGND VGND VPWR VPWR net172 sky130_fd_sc_hd__dlygate4sd3_1
Xhold38 u_tx_fifo.mem\[2\]\[7\] VGND VGND VPWR VPWR net194 sky130_fd_sc_hd__dlygate4sd3_1
Xhold27 u_rx_fifo.mem\[14\]\[7\] VGND VGND VPWR VPWR net183 sky130_fd_sc_hd__dlygate4sd3_1
Xhold49 u_tx_fifo.mem\[8\]\[5\] VGND VGND VPWR VPWR net205 sky130_fd_sc_hd__dlygate4sd3_1
X_2389_ u_parser.u_decoder.index\[1\] u_parser.u_decoder.index\[0\] VGND VGND VPWR
+ VPWR _1143_ sky130_fd_sc_hd__nand2b_2
XFILLER_56_445 VGND VGND VPWR VPWR sky130_fd_sc_hd__decap_6
XFILLER_45_15 VPWR VGND VPWR VGND sky130_ef_sc_hd__decap_12
XTAP_TAPCELL_ROW_82_977 VGND VPWR sky130_fd_sc_hd__tapvpwrvgnd_1
XFILLER_24_353 VGND VGND VPWR VPWR sky130_fd_sc_hd__decap_3
XFILLER_79_515 VGND VGND VPWR VPWR sky130_fd_sc_hd__decap_6
XFILLER_19_169 VPWR VGND VPWR VGND sky130_ef_sc_hd__decap_12
XFILLER_15_320 VGND VGND VPWR VPWR sky130_fd_sc_hd__decap_3
XFILLER_74_297 VGND VGND VPWR VPWR sky130_fd_sc_hd__decap_8
XTAP_TAPCELL_ROW_17_359 VGND VPWR sky130_fd_sc_hd__tapvpwrvgnd_1
XFILLER_15_364 VGND VGND VPWR VPWR sky130_fd_sc_hd__fill_1
XFILLER_42_183 VPWR VGND VPWR VGND sky130_ef_sc_hd__decap_12
X_1760_ u_uart_tx.clk_count\[7\] _0822_ u_uart_tx.clk_count\[10\] u_uart_tx.clk_count\[9\]
+ u_uart_tx.clk_count\[8\] VGND VGND VPWR VPWR _0823_ sky130_fd_sc_hd__a2111o_1
XFILLER_7_541 VPWR VGND VPWR VGND sky130_ef_sc_hd__decap_12
X_1691_ u_rx_fifo.mem\[0\]\[1\] u_rx_fifo.mem\[1\]\[1\] u_rx_fifo.mem\[2\]\[1\] u_rx_fifo.mem\[3\]\[1\]
+ net153 net150 VGND VGND VPWR VPWR _0758_ sky130_fd_sc_hd__mux4_1
X_3430_ clknet_leaf_61_clk _0263_ net88 VGND VGND VPWR VPWR u_uart_tx.tx_data\[6\]
+ sky130_fd_sc_hd__dfrtp_1
X_3361_ clknet_leaf_48_clk _0194_ net102 VGND VGND VPWR VPWR u_parser.u_packet_encoder.crc_latched\[5\]
+ sky130_fd_sc_hd__dfrtp_1
XFILLER_32_3 VPWR VGND VPWR VGND sky130_ef_sc_hd__decap_12
X_2312_ u_tx_fifo.mem\[0\]\[6\] u_tx_fifo.mem\[1\]\[6\] u_tx_fifo.mem\[2\]\[6\] u_tx_fifo.mem\[3\]\[6\]
+ net69 net65 VGND VGND VPWR VPWR _1116_ sky130_fd_sc_hd__mux4_1
X_3292_ clknet_leaf_1_clk _0128_ VGND VGND VPWR VPWR u_tx_fifo.mem\[5\]\[3\] sky130_fd_sc_hd__dfxtp_1
XFILLER_85_529 VPWR VGND VPWR VGND sky130_ef_sc_hd__decap_12
X_2243_ net390 net26 _1067_ VGND VGND VPWR VPWR _0242_ sky130_fd_sc_hd__mux2_1
XFILLER_38_412 VGND VGND VPWR VPWR sky130_fd_sc_hd__decap_8
X_2174_ _1047_ _1048_ VGND VGND VPWR VPWR _1049_ sky130_fd_sc_hd__xnor2_1
XFILLER_38_434 VGND VGND VPWR VPWR sky130_fd_sc_hd__fill_1
XTAP_TAPCELL_ROW_0_205 VGND VPWR sky130_fd_sc_hd__tapvpwrvgnd_1
XFILLER_38_467 VGND VGND VPWR VPWR sky130_fd_sc_hd__decap_8
XFILLER_25_139 VGND VGND VPWR VPWR sky130_fd_sc_hd__fill_1
XFILLER_21_334 VGND VGND VPWR VPWR sky130_fd_sc_hd__fill_2
XFILLER_21_389 VGND VGND VPWR VPWR sky130_fd_sc_hd__decap_3
X_1958_ net222 net80 _0945_ VGND VGND VPWR VPWR _0079_ sky130_fd_sc_hd__mux2_1
X_1889_ _0905_ _0916_ VGND VGND VPWR VPWR _0917_ sky130_fd_sc_hd__nor2_1
X_3628_ clknet_leaf_40_clk _0455_ net106 VGND VGND VPWR VPWR u_parser.u_decoder.ascii_buf\[1\]\[7\]
+ sky130_fd_sc_hd__dfrtp_1
XFILLER_88_312 VGND VGND VPWR VPWR sky130_fd_sc_hd__decap_8
X_3559_ clknet_leaf_36_clk _0386_ net127 VGND VGND VPWR VPWR u_parser.u_decoder.decoded_checksum_calc\[2\]
+ sky130_fd_sc_hd__dfrtp_1
XFILLER_0_249 VGND VGND VPWR VPWR sky130_fd_sc_hd__decap_3
XFILLER_29_434 VPWR VGND VPWR VGND sky130_ef_sc_hd__decap_12
XFILLER_56_253 VGND VGND VPWR VPWR sky130_fd_sc_hd__decap_6
XTAP_TAPCELL_ROW_42_605 VGND VPWR sky130_fd_sc_hd__tapvpwrvgnd_1
XFILLER_72_57 VGND VGND VPWR VPWR sky130_fd_sc_hd__fill_2
XFILLER_24_194 VGND VGND VPWR VPWR sky130_fd_sc_hd__fill_2
XFILLER_12_389 VGND VGND VPWR VPWR sky130_fd_sc_hd__decap_3
XFILLER_4_533 VPWR VGND VPWR VGND sky130_ef_sc_hd__decap_12
XFILLER_79_356 VGND VGND VPWR VPWR sky130_fd_sc_hd__fill_2
XFILLER_47_231 VPWR VGND VPWR VGND sky130_ef_sc_hd__decap_12
X_2930_ u_uart_tx.state\[2\] net593 VGND VGND VPWR VPWR _0531_ sky130_fd_sc_hd__and2_1
X_2861_ u_tx_fifo.wr_ptr\[2\] u_tx_fifo.wr_ptr\[3\] VGND VGND VPWR VPWR _1435_ sky130_fd_sc_hd__nand2b_2
X_2792_ u_parser.u_decoder.ascii_buf\[1\]\[1\] net39 _1409_ VGND VGND VPWR VPWR _0449_
+ sky130_fd_sc_hd__mux2_1
X_1812_ _0707_ _0848_ VGND VGND VPWR VPWR _0864_ sky130_fd_sc_hd__nor2_1
X_1743_ u_parser.u_decoder.decoded_checksum_rx\[7\] u_parser.u_decoder.decoded_checksum_calc\[7\]
+ VGND VGND VPWR VPWR _0809_ sky130_fd_sc_hd__nand2b_1
X_1674_ u_rx_fifo.mem\[0\]\[6\] u_rx_fifo.mem\[1\]\[6\] u_rx_fifo.mem\[2\]\[6\] u_rx_fifo.mem\[3\]\[6\]
+ net154 net150 VGND VGND VPWR VPWR _0741_ sky130_fd_sc_hd__mux4_1
XFILLER_7_393 VPWR VGND VPWR VGND sky130_ef_sc_hd__decap_12
Xhold316 u_parser.u_decoder.decoded_payload\[4\] VGND VGND VPWR VPWR net472 sky130_fd_sc_hd__dlygate4sd3_1
Xhold305 tag_raw\[13\] VGND VGND VPWR VPWR net461 sky130_fd_sc_hd__dlygate4sd3_1
Xhold338 u_uart_rx.rx_shift\[5\] VGND VGND VPWR VPWR net494 sky130_fd_sc_hd__dlygate4sd3_1
Xhold349 u_parser.u_packet_encoder.tag_latched\[10\] VGND VGND VPWR VPWR net505 sky130_fd_sc_hd__dlygate4sd3_1
X_3413_ clknet_leaf_6_clk _0246_ VGND VGND VPWR VPWR u_tx_fifo.mem\[2\]\[5\] sky130_fd_sc_hd__dfxtp_1
Xhold327 u_parser.u_decoder.decoded_payload\[20\] VGND VGND VPWR VPWR net483 sky130_fd_sc_hd__dlygate4sd3_1
XTAP_TAPCELL_ROW_90_1055 VGND VPWR sky130_fd_sc_hd__tapvpwrvgnd_1
X_3344_ clknet_leaf_58_clk _0177_ VGND VGND VPWR VPWR u_tx_fifo.mem\[3\]\[4\] sky130_fd_sc_hd__dfxtp_1
X_3275_ clknet_leaf_0_clk _0111_ VGND VGND VPWR VPWR u_tx_fifo.mem\[12\]\[2\] sky130_fd_sc_hd__dfxtp_1
XFILLER_85_337 VGND VGND VPWR VPWR sky130_fd_sc_hd__decap_3
X_2226_ tag_raw\[33\] net583 net57 VGND VGND VPWR VPWR _0230_ sky130_fd_sc_hd__mux2_1
XFILLER_38_253 VGND VGND VPWR VPWR sky130_fd_sc_hd__decap_6
X_2157_ _1032_ _1033_ VGND VGND VPWR VPWR _1034_ sky130_fd_sc_hd__xnor2_1
X_2088_ net42 net631 _0967_ VGND VGND VPWR VPWR _0187_ sky130_fd_sc_hd__mux2_1
XFILLER_42_27 VGND VGND VPWR VPWR sky130_fd_sc_hd__fill_1
XFILLER_5_308 VGND VGND VPWR VPWR sky130_fd_sc_hd__fill_1
XFILLER_1_503 VGND VGND VPWR VPWR sky130_fd_sc_hd__fill_1
XFILLER_76_315 VGND VGND VPWR VPWR sky130_fd_sc_hd__fill_1
XFILLER_76_304 VGND VGND VPWR VPWR sky130_fd_sc_hd__decap_4
XFILLER_67_57 VGND VGND VPWR VPWR sky130_fd_sc_hd__decap_6
XFILLER_16_61 VGND VGND VPWR VPWR sky130_fd_sc_hd__fill_1
XTAP_TAPCELL_ROW_27_454 VGND VPWR sky130_fd_sc_hd__tapvpwrvgnd_1
XFILLER_16_83 VGND VGND VPWR VPWR sky130_fd_sc_hd__fill_1
X_3060_ net613 _1522_ _1526_ VGND VGND VPWR VPWR _0600_ sky130_fd_sc_hd__a21oi_1
XFILLER_67_337 VPWR VGND VPWR VGND sky130_ef_sc_hd__decap_12
X_2011_ net323 net70 _0953_ VGND VGND VPWR VPWR _0124_ sky130_fd_sc_hd__mux2_1
XFILLER_90_362 VGND VGND VPWR VPWR sky130_fd_sc_hd__fill_2
XFILLER_35_278 VGND VGND VPWR VPWR sky130_fd_sc_hd__fill_2
XFILLER_16_492 VGND VGND VPWR VPWR sky130_fd_sc_hd__fill_1
X_2913_ _1454_ _1455_ VGND VGND VPWR VPWR _0524_ sky130_fd_sc_hd__nor2_1
XTAP_TAPCELL_ROW_61_777 VGND VPWR sky130_fd_sc_hd__tapvpwrvgnd_1
X_2844_ _1424_ _1425_ u_tx_fifo.level\[3\] VGND VGND VPWR VPWR _1427_ sky130_fd_sc_hd__mux2_1
X_2775_ net155 _0846_ u_parser.u_decoder.decoded_checksum_rx\[6\] VGND VGND VPWR VPWR
+ _1404_ sky130_fd_sc_hd__o21a_1
Xhold113 u_tx_fifo.mem\[7\]\[6\] VGND VGND VPWR VPWR net269 sky130_fd_sc_hd__dlygate4sd3_1
Xhold102 u_tx_fifo.mem\[5\]\[7\] VGND VGND VPWR VPWR net258 sky130_fd_sc_hd__dlygate4sd3_1
Xhold124 u_rx_fifo.mem\[13\]\[5\] VGND VGND VPWR VPWR net280 sky130_fd_sc_hd__dlygate4sd3_1
Xhold135 u_rx_fifo.mem\[13\]\[1\] VGND VGND VPWR VPWR net291 sky130_fd_sc_hd__dlygate4sd3_1
X_1726_ u_parser.u_decoder.state\[2\] _0708_ _0792_ VGND VGND VPWR VPWR _0793_ sky130_fd_sc_hd__nand3_1
Xhold157 u_rx_fifo.mem\[7\]\[7\] VGND VGND VPWR VPWR net313 sky130_fd_sc_hd__dlygate4sd3_1
Xhold168 u_tx_fifo.mem\[10\]\[3\] VGND VGND VPWR VPWR net324 sky130_fd_sc_hd__dlygate4sd3_1
Xhold146 u_tx_fifo.mem\[6\]\[3\] VGND VGND VPWR VPWR net302 sky130_fd_sc_hd__dlygate4sd3_1
X_1657_ u_rx_fifo.mem\[4\]\[4\] u_rx_fifo.mem\[5\]\[4\] u_rx_fifo.mem\[6\]\[4\] u_rx_fifo.mem\[7\]\[4\]
+ net153 net149 VGND VGND VPWR VPWR _0724_ sky130_fd_sc_hd__mux4_1
X_1588_ u_rx_fifo.level\[1\] VGND VGND VPWR VPWR _0658_ sky130_fd_sc_hd__inv_2
Xhold179 u_tx_fifo.mem\[1\]\[1\] VGND VGND VPWR VPWR net335 sky130_fd_sc_hd__dlygate4sd3_1
X_3327_ clknet_leaf_21_clk _0163_ VGND VGND VPWR VPWR u_rx_fifo.mem\[12\]\[6\] sky130_fd_sc_hd__dfxtp_1
X_3258_ clknet_leaf_15_clk _0094_ VGND VGND VPWR VPWR u_rx_fifo.mem\[3\]\[1\] sky130_fd_sc_hd__dfxtp_1
XFILLER_37_27 VPWR VGND VPWR VGND sky130_ef_sc_hd__decap_12
XTAP_TAPCELL_ROW_69_855 VGND VPWR sky130_fd_sc_hd__tapvpwrvgnd_1
X_2209_ net470 net515 net56 VGND VGND VPWR VPWR _0213_ sky130_fd_sc_hd__mux2_1
X_3189_ clknet_leaf_13_clk _0025_ VGND VGND VPWR VPWR u_rx_fifo.mem\[6\]\[4\] sky130_fd_sc_hd__dfxtp_1
XFILLER_73_329 VGND VGND VPWR VPWR sky130_fd_sc_hd__decap_6
XFILLER_54_554 VGND VGND VPWR VPWR sky130_fd_sc_hd__fill_1
XFILLER_53_15 VPWR VGND VPWR VGND sky130_ef_sc_hd__decap_12
XTAP_TAPCELL_ROW_52_700 VGND VPWR sky130_fd_sc_hd__tapvpwrvgnd_1
XFILLER_49_315 VPWR VGND VPWR VGND sky130_ef_sc_hd__decap_12
XFILLER_49_337 VGND VGND VPWR VPWR sky130_fd_sc_hd__decap_6
XFILLER_57_370 VGND VGND VPWR VPWR sky130_fd_sc_hd__fill_2
XFILLER_72_340 VGND VGND VPWR VPWR sky130_fd_sc_hd__fill_2
XFILLER_72_362 VGND VGND VPWR VPWR sky130_fd_sc_hd__fill_2
XFILLER_43_81 VGND VGND VPWR VPWR sky130_fd_sc_hd__decap_8
X_2560_ u_parser.u_decoder.ascii_buf\[5\]\[3\] _1253_ _1256_ VGND VGND VPWR VPWR _1264_
+ sky130_fd_sc_hd__a21o_1
X_2491_ u_parser.u_decoder.ascii_buf\[8\]\[3\] _1207_ _1208_ u_parser.u_decoder.ascii_buf\[8\]\[7\]
+ u_parser.u_decoder.ascii_buf\[8\]\[6\] VGND VGND VPWR VPWR _1210_ sky130_fd_sc_hd__a2111o_1
XFILLER_4_193 VGND VGND VPWR VPWR sky130_fd_sc_hd__decap_3
X_3112_ net490 net79 _0845_ VGND VGND VPWR VPWR _0620_ sky130_fd_sc_hd__mux2_1
X_3043_ u_uart_rx.sample_phase\[0\] _1509_ _1512_ u_uart_rx.sample_phase\[1\] VGND
+ VGND VPWR VPWR _1516_ sky130_fd_sc_hd__a31o_1
XFILLER_36_521 VGND VGND VPWR VPWR sky130_fd_sc_hd__decap_8
XTAP_TAPCELL_ROW_66_825 VGND VPWR sky130_fd_sc_hd__tapvpwrvgnd_1
XTAP_TAPCELL_ROW_21_405 VGND VPWR sky130_fd_sc_hd__tapvpwrvgnd_1
XFILLER_31_270 VGND VGND VPWR VPWR sky130_fd_sc_hd__decap_8
X_2827_ net50 _0882_ VGND VGND VPWR VPWR _1414_ sky130_fd_sc_hd__nor2_1
X_2758_ net12 _1387_ _1390_ _1389_ VGND VGND VPWR VPWR _0434_ sky130_fd_sc_hd__a31o_1
X_1709_ u_rx_fifo.mem\[4\]\[5\] u_rx_fifo.mem\[5\]\[5\] u_rx_fifo.mem\[6\]\[5\] u_rx_fifo.mem\[7\]\[5\]
+ net154 net150 VGND VGND VPWR VPWR _0776_ sky130_fd_sc_hd__mux4_1
X_2689_ _1249_ _1365_ VGND VGND VPWR VPWR _1366_ sky130_fd_sc_hd__xnor2_1
XFILLER_48_15 VPWR VGND VPWR VGND sky130_ef_sc_hd__decap_12
XFILLER_86_421 VGND VGND VPWR VPWR sky130_fd_sc_hd__decap_4
XFILLER_14_248 VGND VGND VPWR VPWR sky130_fd_sc_hd__fill_1
Xfanout30 _0940_ VGND VGND VPWR VPWR net30 sky130_fd_sc_hd__clkbuf_2
Xfanout74 rx_fifo_in_data\[5\] VGND VGND VPWR VPWR net74 sky130_fd_sc_hd__buf_2
Xfanout52 net57 VGND VGND VPWR VPWR net52 sky130_fd_sc_hd__clkbuf_2
Xfanout63 u_tx_fifo.rd_ptr\[1\] VGND VGND VPWR VPWR net63 sky130_fd_sc_hd__clkbuf_2
Xfanout41 _0752_ VGND VGND VPWR VPWR net41 sky130_fd_sc_hd__buf_2
Xfanout85 rx_fifo_in_data\[0\] VGND VGND VPWR VPWR net85 sky130_fd_sc_hd__buf_2
XFILLER_10_421 VPWR VGND VPWR VGND sky130_ef_sc_hd__decap_12
Xfanout96 net101 VGND VGND VPWR VPWR net96 sky130_fd_sc_hd__buf_2
XFILLER_6_469 VGND VGND VPWR VPWR sky130_fd_sc_hd__decap_6
XFILLER_89_55 VGND VGND VPWR VPWR sky130_fd_sc_hd__fill_1
XTAP_TAPCELL_ROW_9_285 VGND VPWR sky130_fd_sc_hd__tapvpwrvgnd_1
XFILLER_77_421 VGND VGND VPWR VPWR sky130_fd_sc_hd__fill_1
XFILLER_49_167 VGND VGND VPWR VPWR sky130_fd_sc_hd__fill_1
XFILLER_64_104 VPWR VGND VPWR VGND sky130_ef_sc_hd__decap_12
XFILLER_92_435 VGND VGND VPWR VPWR sky130_fd_sc_hd__decap_4
XFILLER_33_535 VPWR VGND VPWR VGND sky130_ef_sc_hd__decap_12
XFILLER_54_80 VGND VGND VPWR VPWR sky130_fd_sc_hd__decap_4
XFILLER_54_91 VGND VGND VPWR VPWR sky130_fd_sc_hd__fill_1
XFILLER_60_365 VGND VGND VPWR VPWR sky130_fd_sc_hd__decap_4
X_3730_ clknet_leaf_30_clk _0554_ net142 VGND VGND VPWR VPWR u_uart_rx.low_count\[20\]
+ sky130_fd_sc_hd__dfrtp_1
X_1991_ net70 net312 _0949_ VGND VGND VPWR VPWR _0108_ sky130_fd_sc_hd__mux2_1
XTAP_TAPCELL_ROW_71_872 VGND VPWR sky130_fd_sc_hd__tapvpwrvgnd_1
X_3661_ clknet_leaf_62_clk _0488_ net114 VGND VGND VPWR VPWR u_tx_fifo.wr_ptr\[3\]
+ sky130_fd_sc_hd__dfrtp_4
Xclkload44 clknet_leaf_13_clk VGND VGND VPWR VPWR clkload44/Y sky130_fd_sc_hd__clkinvlp_4
Xclkload11 clknet_leaf_62_clk VGND VGND VPWR VPWR clkload11/Y sky130_fd_sc_hd__clkinv_2
Xclkload22 clknet_leaf_56_clk VGND VGND VPWR VPWR clkload22/Y sky130_fd_sc_hd__clkinv_2
Xclkload33 clknet_leaf_41_clk VGND VGND VPWR VPWR clkload33/Y sky130_fd_sc_hd__clkinv_4
X_2612_ net459 _1305_ net8 VGND VGND VPWR VPWR _0373_ sky130_fd_sc_hd__mux2_1
X_3592_ clknet_leaf_44_clk _0419_ net132 VGND VGND VPWR VPWR u_parser.u_decoder.ascii_buf\[9\]\[3\]
+ sky130_fd_sc_hd__dfrtp_1
XFILLER_62_3 VPWR VGND VPWR VGND sky130_ef_sc_hd__decap_12
X_2543_ net456 _1250_ net8 VGND VGND VPWR VPWR _0359_ sky130_fd_sc_hd__mux2_1
Xclkload55 clknet_leaf_36_clk VGND VGND VPWR VPWR clkload55/Y sky130_fd_sc_hd__clkinv_2
X_2474_ u_parser.u_decoder.ascii_buf\[9\]\[3\] u_parser.u_decoder.ascii_buf\[9\]\[4\]
+ u_parser.u_decoder.ascii_buf\[9\]\[7\] u_parser.u_decoder.ascii_buf\[9\]\[6\] VGND
+ VGND VPWR VPWR _1197_ sky130_fd_sc_hd__or4b_1
XFILLER_68_410 VGND VGND VPWR VPWR sky130_fd_sc_hd__decap_8
XTAP_TAPCELL_ROW_79_950 VGND VPWR sky130_fd_sc_hd__tapvpwrvgnd_1
XTAP_TAPCELL_ROW_87_1027 VGND VPWR sky130_fd_sc_hd__tapvpwrvgnd_1
X_3026_ net282 net84 _1507_ VGND VGND VPWR VPWR _0585_ sky130_fd_sc_hd__mux2_1
XFILLER_36_362 VGND VGND VPWR VPWR sky130_fd_sc_hd__fill_2
XFILLER_24_524 VGND VGND VPWR VPWR sky130_fd_sc_hd__decap_8
XFILLER_11_229 VGND VGND VPWR VPWR sky130_fd_sc_hd__decap_6
Xclkload5 clknet_3_6__leaf_clk VGND VGND VPWR VPWR clkload5/Y sky130_fd_sc_hd__inv_6
XFILLER_50_27 VGND VGND VPWR VPWR sky130_fd_sc_hd__fill_1
XFILLER_3_417 VPWR VGND VPWR VGND sky130_ef_sc_hd__decap_12
XTAP_TAPCELL_ROW_6_255 VGND VPWR sky130_fd_sc_hd__tapvpwrvgnd_1
XFILLER_19_318 VGND VGND VPWR VPWR sky130_fd_sc_hd__fill_1
XFILLER_15_546 VGND VGND VPWR VPWR sky130_fd_sc_hd__decap_8
XFILLER_42_343 VGND VGND VPWR VPWR sky130_fd_sc_hd__fill_1
XFILLER_10_262 VGND VGND VPWR VPWR sky130_fd_sc_hd__decap_8
XFILLER_10_251 VGND VGND VPWR VPWR sky130_fd_sc_hd__fill_1
XTAP_TAPCELL_ROW_40_577 VGND VPWR sky130_fd_sc_hd__tapvpwrvgnd_1
XFILLER_40_82 VGND VGND VPWR VPWR sky130_fd_sc_hd__fill_2
X_2190_ _1061_ net532 net52 VGND VGND VPWR VPWR _0195_ sky130_fd_sc_hd__mux2_1
XFILLER_77_262 VPWR VGND VPWR VGND sky130_ef_sc_hd__decap_12
XTAP_TAPCELL_ROW_76_920 VGND VPWR sky130_fd_sc_hd__tapvpwrvgnd_1
XFILLER_65_402 VGND VGND VPWR VPWR sky130_fd_sc_hd__decap_8
XTAP_TAPCELL_ROW_48_655 VGND VPWR sky130_fd_sc_hd__tapvpwrvgnd_1
XTAP_TAPCELL_ROW_31_500 VGND VPWR sky130_fd_sc_hd__tapvpwrvgnd_1
X_1974_ u_rx_fifo.wr_ptr\[3\] u_rx_fifo.wr_ptr\[2\] _0870_ VGND VGND VPWR VPWR _0948_
+ sky130_fd_sc_hd__or3b_4
X_3713_ clknet_leaf_32_clk _0537_ net140 VGND VGND VPWR VPWR u_uart_rx.low_count\[3\]
+ sky130_fd_sc_hd__dfrtp_1
X_3644_ clknet_leaf_36_clk _0471_ net131 VGND VGND VPWR VPWR u_parser.u_decoder.ascii_buf\[3\]\[7\]
+ sky130_fd_sc_hd__dfrtp_1
XFILLER_20_19 VGND VGND VPWR VPWR sky130_fd_sc_hd__fill_1
X_3575_ clknet_leaf_24_clk _0402_ net128 VGND VGND VPWR VPWR u_parser.u_decoder.ascii_buf\[10\]\[2\]
+ sky130_fd_sc_hd__dfrtp_1
X_2526_ u_parser.u_decoder.ascii_buf\[6\]\[1\] u_parser.u_decoder.ascii_buf\[6\]\[2\]
+ u_parser.u_decoder.ascii_buf\[6\]\[3\] VGND VGND VPWR VPWR _1237_ sky130_fd_sc_hd__o21ai_1
XTAP_TAPCELL_ROW_93_1097 VGND VPWR sky130_fd_sc_hd__tapvpwrvgnd_1
XTAP_TAPCELL_ROW_93_1086 VGND VPWR sky130_fd_sc_hd__tapvpwrvgnd_1
X_2457_ _1184_ VGND VGND VPWR VPWR _1185_ sky130_fd_sc_hd__inv_2
Xhold28 u_rx_fifo.mem\[12\]\[0\] VGND VGND VPWR VPWR net184 sky130_fd_sc_hd__dlygate4sd3_1
Xhold17 u_rx_fifo.mem\[13\]\[7\] VGND VGND VPWR VPWR net173 sky130_fd_sc_hd__dlygate4sd3_1
Xhold39 u_tx_fifo.mem\[2\]\[6\] VGND VGND VPWR VPWR net195 sky130_fd_sc_hd__dlygate4sd3_1
X_2388_ _0965_ _1141_ VGND VGND VPWR VPWR _1142_ sky130_fd_sc_hd__or2_4
XFILLER_45_27 VPWR VGND VPWR VGND sky130_ef_sc_hd__decap_12
X_3009_ net25 net332 _1505_ VGND VGND VPWR VPWR _0570_ sky130_fd_sc_hd__mux2_1
XFILLER_36_170 VGND VGND VPWR VPWR sky130_fd_sc_hd__fill_1
XFILLER_71_427 VPWR VGND VPWR VGND sky130_ef_sc_hd__decap_12
XFILLER_71_449 VPWR VGND VPWR VGND sky130_ef_sc_hd__decap_12
XTAP_TAPCELL_ROW_82_978 VGND VPWR sky130_fd_sc_hd__tapvpwrvgnd_1
Xclkbuf_leaf_63_clk clknet_3_0__leaf_clk VGND VGND VPWR VPWR clknet_leaf_63_clk sky130_fd_sc_hd__clkbuf_8
XFILLER_24_365 VPWR VGND VPWR VGND sky130_ef_sc_hd__decap_12
XFILLER_61_15 VPWR VGND VPWR VGND sky130_ef_sc_hd__decap_12
XFILLER_51_195 VGND VGND VPWR VPWR sky130_fd_sc_hd__decap_4
XFILLER_3_225 VGND VGND VPWR VPWR sky130_fd_sc_hd__fill_1
XFILLER_79_549 VGND VGND VPWR VPWR sky130_fd_sc_hd__decap_6
XFILLER_10_85 VGND VGND VPWR VPWR sky130_fd_sc_hd__decap_3
XFILLER_86_56 VGND VGND VPWR VPWR sky130_fd_sc_hd__fill_1
XTAP_TAPCELL_ROW_45_625 VGND VPWR sky130_fd_sc_hd__tapvpwrvgnd_1
Xclkbuf_leaf_54_clk clknet_3_2__leaf_clk VGND VGND VPWR VPWR clknet_leaf_54_clk sky130_fd_sc_hd__clkbuf_8
XFILLER_35_82 VPWR VGND VPWR VGND sky130_ef_sc_hd__decap_12
XFILLER_30_346 VGND VGND VPWR VPWR sky130_fd_sc_hd__fill_1
XFILLER_42_195 VGND VGND VPWR VPWR sky130_fd_sc_hd__fill_1
XFILLER_51_81 VPWR VGND VPWR VGND sky130_ef_sc_hd__decap_12
X_1690_ u_rx_fifo.mem\[4\]\[1\] u_rx_fifo.mem\[5\]\[1\] u_rx_fifo.mem\[6\]\[1\] u_rx_fifo.mem\[7\]\[1\]
+ net153 net149 VGND VGND VPWR VPWR _0757_ sky130_fd_sc_hd__mux4_1
XFILLER_7_553 VGND VGND VPWR VPWR sky130_fd_sc_hd__fill_2
X_3360_ clknet_leaf_51_clk _0193_ net92 VGND VGND VPWR VPWR u_parser.u_packet_encoder.crc_latched\[4\]
+ sky130_fd_sc_hd__dfrtp_1
X_2311_ net441 _1115_ net49 VGND VGND VPWR VPWR _0262_ sky130_fd_sc_hd__mux2_1
X_3291_ clknet_leaf_3_clk _0127_ VGND VGND VPWR VPWR u_tx_fifo.mem\[5\]\[2\] sky130_fd_sc_hd__dfxtp_1
XFILLER_25_3 VGND VGND VPWR VPWR sky130_fd_sc_hd__decap_3
X_2242_ net191 net28 _1067_ VGND VGND VPWR VPWR _0241_ sky130_fd_sc_hd__mux2_1
X_2173_ tag_raw\[3\] _1034_ VGND VGND VPWR VPWR _1048_ sky130_fd_sc_hd__xnor2_1
XTAP_TAPCELL_ROW_0_206 VGND VPWR sky130_fd_sc_hd__tapvpwrvgnd_1
XFILLER_80_213 VGND VGND VPWR VPWR sky130_fd_sc_hd__decap_4
XFILLER_53_438 VGND VGND VPWR VPWR sky130_fd_sc_hd__fill_1
Xclkbuf_leaf_45_clk clknet_3_3__leaf_clk VGND VGND VPWR VPWR clknet_leaf_45_clk sky130_fd_sc_hd__clkbuf_8
XFILLER_21_357 VPWR VGND VPWR VGND sky130_ef_sc_hd__decap_12
X_1957_ net325 net83 _0945_ VGND VGND VPWR VPWR _0078_ sky130_fd_sc_hd__mux2_1
X_1888_ _0878_ _0898_ VGND VGND VPWR VPWR _0916_ sky130_fd_sc_hd__nand2_1
X_3627_ clknet_leaf_38_clk _0454_ net127 VGND VGND VPWR VPWR u_parser.u_decoder.ascii_buf\[1\]\[6\]
+ sky130_fd_sc_hd__dfrtp_1
X_3558_ clknet_leaf_35_clk _0385_ net131 VGND VGND VPWR VPWR u_parser.u_decoder.decoded_checksum_calc\[1\]
+ sky130_fd_sc_hd__dfrtp_1
XFILLER_88_324 VGND VGND VPWR VPWR sky130_fd_sc_hd__decap_6
X_2509_ u_parser.u_decoder.ascii_buf\[7\]\[7\] u_parser.u_decoder.ascii_buf\[7\]\[6\]
+ _1222_ _1223_ VGND VGND VPWR VPWR _1224_ sky130_fd_sc_hd__or4_1
XFILLER_88_346 VGND VGND VPWR VPWR sky130_fd_sc_hd__decap_8
X_3489_ clknet_leaf_35_clk _0316_ net131 VGND VGND VPWR VPWR u_parser.u_decoder.ascii_buf\[5\]\[3\]
+ sky130_fd_sc_hd__dfrtp_1
XFILLER_29_413 VGND VGND VPWR VPWR sky130_fd_sc_hd__fill_1
XFILLER_29_446 VGND VGND VPWR VPWR sky130_fd_sc_hd__fill_2
XFILLER_56_15 VPWR VGND VPWR VGND sky130_ef_sc_hd__decap_12
Xclkbuf_leaf_36_clk clknet_3_6__leaf_clk VGND VGND VPWR VPWR clknet_leaf_36_clk sky130_fd_sc_hd__clkbuf_8
XTAP_TAPCELL_ROW_50_672 VGND VPWR sky130_fd_sc_hd__tapvpwrvgnd_1
XFILLER_4_501 VPWR VGND VPWR VGND sky130_ef_sc_hd__decap_12
XFILLER_4_545 VGND VGND VPWR VPWR sky130_fd_sc_hd__decap_8
XFILLER_79_335 VGND VGND VPWR VPWR sky130_fd_sc_hd__fill_1
XFILLER_47_221 VGND VGND VPWR VPWR sky130_fd_sc_hd__decap_3
XFILLER_35_405 VPWR VGND VPWR VGND sky130_ef_sc_hd__decap_12
XFILLER_47_243 VPWR VGND VPWR VGND sky130_ef_sc_hd__decap_12
XTAP_TAPCELL_ROW_58_750 VGND VPWR sky130_fd_sc_hd__tapvpwrvgnd_1
XFILLER_90_533 VPWR VGND VPWR VGND sky130_ef_sc_hd__decap_12
Xclkbuf_leaf_27_clk clknet_3_7__leaf_clk VGND VGND VPWR VPWR clknet_leaf_27_clk sky130_fd_sc_hd__clkbuf_8
XFILLER_35_449 VGND VGND VPWR VPWR sky130_fd_sc_hd__decap_4
XFILLER_15_151 VGND VGND VPWR VPWR sky130_fd_sc_hd__fill_1
X_2860_ u_rx_fifo.rd_ptr\[3\] _1433_ VGND VGND VPWR VPWR _0492_ sky130_fd_sc_hd__xnor2_1
X_1811_ _0797_ _0858_ u_rx_fifo.level\[3\] u_rx_fifo.level\[2\] VGND VGND VPWR VPWR
+ _0863_ sky130_fd_sc_hd__and4b_1
X_2791_ u_parser.u_decoder.ascii_buf\[1\]\[0\] net41 _1409_ VGND VGND VPWR VPWR _0448_
+ sky130_fd_sc_hd__mux2_1
X_1742_ u_parser.u_decoder.decoded_checksum_rx\[5\] u_parser.u_decoder.decoded_checksum_calc\[5\]
+ VGND VGND VPWR VPWR _0808_ sky130_fd_sc_hd__nand2b_1
Xhold317 u_uart_rx.vote_ones\[0\] VGND VGND VPWR VPWR net473 sky130_fd_sc_hd__dlygate4sd3_1
X_1673_ u_rx_fifo.mem\[4\]\[6\] u_rx_fifo.mem\[5\]\[6\] u_rx_fifo.mem\[6\]\[6\] u_rx_fifo.mem\[7\]\[6\]
+ net153 net149 VGND VGND VPWR VPWR _0740_ sky130_fd_sc_hd__mux4_1
Xhold306 u_uart_tx.tx_data\[2\] VGND VGND VPWR VPWR net462 sky130_fd_sc_hd__dlygate4sd3_1
Xhold339 u_uart_tx.tx_data\[6\] VGND VGND VPWR VPWR net495 sky130_fd_sc_hd__dlygate4sd3_1
X_3412_ clknet_leaf_58_clk _0245_ VGND VGND VPWR VPWR u_tx_fifo.mem\[2\]\[4\] sky130_fd_sc_hd__dfxtp_1
Xhold328 u_parser.u_packet_encoder.tag_latched\[23\] VGND VGND VPWR VPWR net484 sky130_fd_sc_hd__dlygate4sd3_1
XTAP_TAPCELL_ROW_90_1056 VGND VPWR sky130_fd_sc_hd__tapvpwrvgnd_1
X_3343_ clknet_leaf_58_clk _0176_ VGND VGND VPWR VPWR u_tx_fifo.mem\[3\]\[3\] sky130_fd_sc_hd__dfxtp_1
X_3274_ clknet_leaf_62_clk _0110_ VGND VGND VPWR VPWR u_tx_fifo.mem\[12\]\[1\] sky130_fd_sc_hd__dfxtp_1
XFILLER_58_508 VPWR VGND VPWR VGND sky130_ef_sc_hd__decap_12
X_2225_ tag_raw\[32\] net520 net56 VGND VGND VPWR VPWR _0229_ sky130_fd_sc_hd__mux2_1
X_2156_ tag_raw\[9\] _1009_ VGND VGND VPWR VPWR _1033_ sky130_fd_sc_hd__xnor2_1
XFILLER_26_29 VGND VGND VPWR VPWR sky130_fd_sc_hd__fill_1
XFILLER_93_393 VPWR VGND VPWR VGND sky130_ef_sc_hd__decap_12
Xclkbuf_leaf_18_clk clknet_3_5__leaf_clk VGND VGND VPWR VPWR clknet_leaf_18_clk sky130_fd_sc_hd__clkbuf_8
XFILLER_81_544 VGND VGND VPWR VPWR sky130_fd_sc_hd__decap_8
XPHY_EDGE_ROW_5_Right_5 VGND VGND VPWR VPWR sky130_fd_sc_hd__decap_3
X_2087_ _0779_ net614 _0967_ VGND VGND VPWR VPWR _0186_ sky130_fd_sc_hd__mux2_1
X_2989_ _0668_ net464 VGND VGND VPWR VPWR _0557_ sky130_fd_sc_hd__and2_1
XTAP_TAPCELL_ROW_55_720 VGND VPWR sky130_fd_sc_hd__tapvpwrvgnd_1
XFILLER_72_533 VPWR VGND VPWR VGND sky130_ef_sc_hd__decap_12
XTAP_TAPCELL_ROW_27_455 VGND VPWR sky130_fd_sc_hd__tapvpwrvgnd_1
XFILLER_32_419 VGND VGND VPWR VPWR sky130_fd_sc_hd__fill_1
XFILLER_25_493 VGND VGND VPWR VPWR sky130_fd_sc_hd__decap_8
XTAP_TAPCELL_ROW_10_300 VGND VPWR sky130_fd_sc_hd__tapvpwrvgnd_1
XFILLER_67_349 VGND VGND VPWR VPWR sky130_fd_sc_hd__fill_1
X_2010_ net216 net72 _0953_ VGND VGND VPWR VPWR _0123_ sky130_fd_sc_hd__mux2_1
XFILLER_75_393 VPWR VGND VPWR VGND sky130_ef_sc_hd__decap_12
XFILLER_23_408 VGND VGND VPWR VPWR sky130_fd_sc_hd__decap_3
X_2912_ u_uart_tx.clk_count\[7\] _1452_ net6 VGND VGND VPWR VPWR _1455_ sky130_fd_sc_hd__o21ai_1
XFILLER_92_3 VPWR VGND VPWR VGND sky130_ef_sc_hd__decap_12
XTAP_TAPCELL_ROW_61_778 VGND VPWR sky130_fd_sc_hd__tapvpwrvgnd_1
X_2843_ net556 _1426_ VGND VGND VPWR VPWR _0483_ sky130_fd_sc_hd__xor2_1
X_2774_ net12 _1402_ _1403_ _1401_ VGND VGND VPWR VPWR _0437_ sky130_fd_sc_hd__a31o_1
X_1725_ u_parser.u_decoder.timeout_count\[18\] _0790_ _0791_ VGND VGND VPWR VPWR _0792_
+ sky130_fd_sc_hd__nand3_1
Xhold114 u_tx_fifo.mem\[15\]\[3\] VGND VGND VPWR VPWR net270 sky130_fd_sc_hd__dlygate4sd3_1
Xhold103 u_tx_fifo.mem\[14\]\[5\] VGND VGND VPWR VPWR net259 sky130_fd_sc_hd__dlygate4sd3_1
Xhold125 u_rx_fifo.mem\[11\]\[4\] VGND VGND VPWR VPWR net281 sky130_fd_sc_hd__dlygate4sd3_1
X_1656_ u_rx_fifo.mem\[0\]\[4\] u_rx_fifo.mem\[1\]\[4\] u_rx_fifo.mem\[2\]\[4\] u_rx_fifo.mem\[3\]\[4\]
+ net153 net149 VGND VGND VPWR VPWR _0723_ sky130_fd_sc_hd__mux4_1
Xhold158 u_rx_fifo.mem\[7\]\[1\] VGND VGND VPWR VPWR net314 sky130_fd_sc_hd__dlygate4sd3_1
Xhold136 u_tx_fifo.mem\[10\]\[4\] VGND VGND VPWR VPWR net292 sky130_fd_sc_hd__dlygate4sd3_1
Xhold147 u_tx_fifo.mem\[7\]\[3\] VGND VGND VPWR VPWR net303 sky130_fd_sc_hd__dlygate4sd3_1
Xclkbuf_leaf_7_clk clknet_3_1__leaf_clk VGND VGND VPWR VPWR clknet_leaf_7_clk sky130_fd_sc_hd__clkbuf_8
Xhold169 u_rx_fifo.mem\[14\]\[1\] VGND VGND VPWR VPWR net325 sky130_fd_sc_hd__dlygate4sd3_1
X_3326_ clknet_leaf_8_clk _0162_ VGND VGND VPWR VPWR u_rx_fifo.mem\[12\]\[5\] sky130_fd_sc_hd__dfxtp_1
XFILLER_85_113 VGND VGND VPWR VPWR sky130_fd_sc_hd__decap_4
X_3257_ clknet_leaf_14_clk _0093_ VGND VGND VPWR VPWR u_rx_fifo.mem\[3\]\[0\] sky130_fd_sc_hd__dfxtp_1
XFILLER_37_39 VGND VGND VPWR VPWR sky130_fd_sc_hd__fill_1
XTAP_TAPCELL_ROW_69_856 VGND VPWR sky130_fd_sc_hd__tapvpwrvgnd_1
X_3188_ clknet_leaf_13_clk _0024_ VGND VGND VPWR VPWR u_rx_fifo.mem\[6\]\[3\] sky130_fd_sc_hd__dfxtp_1
X_2208_ tag_raw\[15\] net467 net54 VGND VGND VPWR VPWR _0212_ sky130_fd_sc_hd__mux2_1
X_2139_ tag_raw\[8\] _1016_ VGND VGND VPWR VPWR _1017_ sky130_fd_sc_hd__xnor2_1
XFILLER_81_352 VGND VGND VPWR VPWR sky130_fd_sc_hd__fill_1
XFILLER_53_27 VPWR VGND VPWR VGND sky130_ef_sc_hd__decap_12
XTAP_TAPCELL_ROW_24_425 VGND VPWR sky130_fd_sc_hd__tapvpwrvgnd_1
XFILLER_5_139 VGND VGND VPWR VPWR sky130_fd_sc_hd__decap_6
XFILLER_78_79 VGND VGND VPWR VPWR sky130_fd_sc_hd__fill_1
XFILLER_76_135 VGND VGND VPWR VPWR sky130_fd_sc_hd__decap_4
XFILLER_64_319 VGND VGND VPWR VPWR sky130_fd_sc_hd__decap_3
XFILLER_57_393 VGND VGND VPWR VPWR sky130_fd_sc_hd__fill_2
XFILLER_72_330 VGND VGND VPWR VPWR sky130_fd_sc_hd__fill_2
XFILLER_40_271 VGND VGND VPWR VPWR sky130_fd_sc_hd__decap_8
X_2490_ u_parser.u_decoder.ascii_buf\[8\]\[3\] _1207_ _1208_ u_parser.u_decoder.ascii_buf\[8\]\[7\]
+ u_parser.u_decoder.ascii_buf\[8\]\[6\] VGND VGND VPWR VPWR _1209_ sky130_fd_sc_hd__a2111oi_1
X_3111_ net547 net81 _0845_ VGND VGND VPWR VPWR _0619_ sky130_fd_sc_hd__mux2_1
XFILLER_67_113 VGND VGND VPWR VPWR sky130_fd_sc_hd__decap_6
X_3042_ _0687_ _1510_ _1513_ VGND VGND VPWR VPWR _1515_ sky130_fd_sc_hd__a21o_1
XTAP_TAPCELL_ROW_66_826 VGND VPWR sky130_fd_sc_hd__tapvpwrvgnd_1
XFILLER_36_533 VPWR VGND VPWR VGND sky130_ef_sc_hd__decap_12
X_2826_ net50 _0882_ VGND VGND VPWR VPWR _1413_ sky130_fd_sc_hd__and2_1
X_2757_ u_parser.u_decoder.ascii_buf\[11\]\[0\] u_parser.u_decoder.ascii_buf\[11\]\[1\]
+ _1383_ u_parser.u_decoder.ascii_buf\[11\]\[2\] VGND VGND VPWR VPWR _1390_ sky130_fd_sc_hd__a31o_1
X_2688_ _1363_ _1364_ VGND VGND VPWR VPWR _1365_ sky130_fd_sc_hd__xnor2_1
X_1708_ net58 _0774_ u_rx_fifo.rd_ptr\[3\] VGND VGND VPWR VPWR _0775_ sky130_fd_sc_hd__o21a_1
X_1639_ u_rx_fifo.level\[1\] u_rx_fifo.level\[0\] u_rx_fifo.level\[2\] VGND VGND VPWR
+ VPWR _0706_ sky130_fd_sc_hd__or3_1
XFILLER_86_433 VPWR VGND VPWR VGND sky130_ef_sc_hd__decap_12
XFILLER_48_27 VGND VGND VPWR VPWR sky130_fd_sc_hd__fill_1
X_3309_ clknet_leaf_65_clk _0145_ VGND VGND VPWR VPWR u_tx_fifo.mem\[13\]\[4\] sky130_fd_sc_hd__dfxtp_1
XFILLER_64_15 VPWR VGND VPWR VGND sky130_ef_sc_hd__decap_12
XTAP_TAPCELL_ROW_37_550 VGND VPWR sky130_fd_sc_hd__tapvpwrvgnd_1
XFILLER_14_205 VPWR VGND VPWR VGND sky130_ef_sc_hd__decap_12
XFILLER_54_385 VGND VGND VPWR VPWR sky130_fd_sc_hd__decap_6
XFILLER_81_193 VGND VGND VPWR VPWR sky130_fd_sc_hd__fill_1
Xfanout31 _0927_ VGND VGND VPWR VPWR net31 sky130_fd_sc_hd__buf_2
Xfanout20 _0936_ VGND VGND VPWR VPWR net20 sky130_fd_sc_hd__clkbuf_2
XFILLER_10_400 VGND VGND VPWR VPWR sky130_fd_sc_hd__fill_1
Xfanout64 u_tx_fifo.rd_ptr\[1\] VGND VGND VPWR VPWR net64 sky130_fd_sc_hd__clkbuf_4
Xfanout53 net54 VGND VGND VPWR VPWR net53 sky130_fd_sc_hd__clkbuf_4
Xfanout42 _0744_ VGND VGND VPWR VPWR net42 sky130_fd_sc_hd__clkbuf_4
Xfanout75 rx_fifo_in_data\[5\] VGND VGND VPWR VPWR net75 sky130_fd_sc_hd__buf_1
XFILLER_10_433 VPWR VGND VPWR VGND sky130_ef_sc_hd__decap_12
Xfanout97 net98 VGND VGND VPWR VPWR net97 sky130_fd_sc_hd__clkbuf_4
Xfanout86 net87 VGND VGND VPWR VPWR net86 sky130_fd_sc_hd__buf_2
XFILLER_10_477 VPWR VGND VPWR VGND sky130_ef_sc_hd__decap_12
XFILLER_89_260 VGND VGND VPWR VPWR sky130_fd_sc_hd__decap_3
XTAP_TAPCELL_ROW_9_286 VGND VPWR sky130_fd_sc_hd__tapvpwrvgnd_1
XFILLER_49_113 VPWR VGND VPWR VGND sky130_ef_sc_hd__decap_12
XFILLER_77_499 VGND VGND VPWR VPWR sky130_fd_sc_hd__fill_1
XFILLER_64_116 VGND VGND VPWR VPWR sky130_fd_sc_hd__decap_3
XFILLER_18_533 VPWR VGND VPWR VGND sky130_ef_sc_hd__decap_12
XFILLER_33_547 VGND VGND VPWR VPWR sky130_fd_sc_hd__decap_8
XFILLER_60_344 VPWR VGND VPWR VGND sky130_ef_sc_hd__decap_12
X_1990_ net72 net392 _0949_ VGND VGND VPWR VPWR _0107_ sky130_fd_sc_hd__mux2_1
XTAP_TAPCELL_ROW_71_873 VGND VPWR sky130_fd_sc_hd__tapvpwrvgnd_1
X_3660_ clknet_leaf_62_clk _0487_ net90 VGND VGND VPWR VPWR u_tx_fifo.wr_ptr\[2\]
+ sky130_fd_sc_hd__dfrtp_4
Xclkload12 clknet_leaf_63_clk VGND VGND VPWR VPWR clkload12/Y sky130_fd_sc_hd__clkinv_1
Xclkload23 clknet_leaf_57_clk VGND VGND VPWR VPWR clkload23/Y sky130_fd_sc_hd__clkinv_4
Xclkload34 clknet_leaf_42_clk VGND VGND VPWR VPWR clkload34/Y sky130_fd_sc_hd__inv_6
X_3591_ clknet_leaf_43_clk _0418_ net111 VGND VGND VPWR VPWR u_parser.u_decoder.ascii_buf\[9\]\[2\]
+ sky130_fd_sc_hd__dfrtp_1
X_2611_ _1301_ _1304_ VGND VGND VPWR VPWR _1305_ sky130_fd_sc_hd__and2_1
Xclkload45 clknet_leaf_14_clk VGND VGND VPWR VPWR clkload45/Y sky130_fd_sc_hd__clkinvlp_4
X_2542_ u_parser.u_decoder.ascii_buf\[6\]\[3\] _1239_ _1243_ VGND VGND VPWR VPWR _1250_
+ sky130_fd_sc_hd__a21o_1
XFILLER_55_3 VPWR VGND VPWR VGND sky130_ef_sc_hd__decap_12
Xclkload56 clknet_leaf_37_clk VGND VGND VPWR VPWR clkload56/Y sky130_fd_sc_hd__inv_6
X_2473_ u_parser.u_decoder.ascii_buf\[9\]\[0\] _1195_ VGND VGND VPWR VPWR _1196_ sky130_fd_sc_hd__nand2_1
XFILLER_87_219 VGND VGND VPWR VPWR sky130_fd_sc_hd__decap_4
XTAP_TAPCELL_ROW_79_951 VGND VPWR sky130_fd_sc_hd__tapvpwrvgnd_1
XFILLER_83_425 VGND VGND VPWR VPWR sky130_fd_sc_hd__fill_1
XFILLER_68_477 VPWR VGND VPWR VGND sky130_ef_sc_hd__decap_12
XTAP_TAPCELL_ROW_87_1028 VGND VPWR sky130_fd_sc_hd__tapvpwrvgnd_1
X_3025_ _0884_ _0887_ VGND VGND VPWR VPWR _1507_ sky130_fd_sc_hd__nor2_4
XFILLER_83_469 VGND VGND VPWR VPWR sky130_fd_sc_hd__decap_6
XTAP_TAPCELL_ROW_34_520 VGND VPWR sky130_fd_sc_hd__tapvpwrvgnd_1
Xclkload6 clknet_3_7__leaf_clk VGND VGND VPWR VPWR clkload6/X sky130_fd_sc_hd__clkbuf_8
X_3789_ clknet_leaf_28_clk _0607_ net139 VGND VGND VPWR VPWR u_uart_rx.sample_div_count\[9\]
+ sky130_fd_sc_hd__dfrtp_1
X_2809_ u_parser.u_decoder.ascii_buf\[3\]\[0\] net41 _1411_ VGND VGND VPWR VPWR _0464_
+ sky130_fd_sc_hd__mux2_1
XFILLER_3_429 VPWR VGND VPWR VGND sky130_ef_sc_hd__decap_12
XFILLER_59_15 VPWR VGND VPWR VGND sky130_ef_sc_hd__decap_12
XFILLER_86_241 VGND VGND VPWR VPWR sky130_fd_sc_hd__decap_8
XTAP_TAPCELL_ROW_6_256 VGND VPWR sky130_fd_sc_hd__tapvpwrvgnd_1
XFILLER_59_433 VPWR VGND VPWR VGND sky130_ef_sc_hd__decap_12
XFILLER_86_274 VGND VGND VPWR VPWR sky130_fd_sc_hd__fill_2
XFILLER_74_403 VGND VGND VPWR VPWR sky130_fd_sc_hd__decap_3
XFILLER_74_414 VGND VGND VPWR VPWR sky130_fd_sc_hd__fill_1
XFILLER_15_503 VGND VGND VPWR VPWR sky130_fd_sc_hd__fill_1
XFILLER_91_57 VPWR VGND VPWR VGND sky130_ef_sc_hd__decap_12
XFILLER_24_73 VGND VGND VPWR VPWR sky130_fd_sc_hd__decap_3
XTAP_TAPCELL_ROW_40_578 VGND VPWR sky130_fd_sc_hd__tapvpwrvgnd_1
XFILLER_40_61 VGND VGND VPWR VPWR sky130_fd_sc_hd__fill_1
XFILLER_49_81 VPWR VGND VPWR VGND sky130_ef_sc_hd__decap_12
XFILLER_77_274 VGND VGND VPWR VPWR sky130_fd_sc_hd__decap_3
XTAP_TAPCELL_ROW_76_921 VGND VPWR sky130_fd_sc_hd__tapvpwrvgnd_1
XFILLER_80_406 VGND VGND VPWR VPWR sky130_fd_sc_hd__fill_1
XTAP_TAPCELL_ROW_48_656 VGND VPWR sky130_fd_sc_hd__tapvpwrvgnd_1
X_1973_ net316 net29 _0947_ VGND VGND VPWR VPWR _0092_ sky130_fd_sc_hd__mux2_1
XFILLER_33_399 VGND VGND VPWR VPWR sky130_fd_sc_hd__fill_1
X_3712_ clknet_leaf_32_clk _0536_ net143 VGND VGND VPWR VPWR u_uart_rx.low_count\[2\]
+ sky130_fd_sc_hd__dfrtp_1
X_3643_ clknet_leaf_35_clk _0470_ net132 VGND VGND VPWR VPWR u_parser.u_decoder.ascii_buf\[3\]\[6\]
+ sky130_fd_sc_hd__dfrtp_1
X_3574_ clknet_leaf_24_clk _0401_ net128 VGND VGND VPWR VPWR u_parser.u_decoder.ascii_buf\[10\]\[1\]
+ sky130_fd_sc_hd__dfrtp_2
X_2525_ net501 _1236_ net13 VGND VGND VPWR VPWR _0355_ sky130_fd_sc_hd__mux2_1
XTAP_TAPCELL_ROW_93_1098 VGND VPWR sky130_fd_sc_hd__tapvpwrvgnd_1
XTAP_TAPCELL_ROW_93_1087 VGND VPWR sky130_fd_sc_hd__tapvpwrvgnd_1
X_2456_ u_parser.u_decoder.timeout_count\[14\] _1165_ _1181_ VGND VGND VPWR VPWR _1184_
+ sky130_fd_sc_hd__and3_1
Xhold18 u_tx_fifo.mem\[0\]\[4\] VGND VGND VPWR VPWR net174 sky130_fd_sc_hd__dlygate4sd3_1
Xhold29 u_tx_fifo.mem\[5\]\[0\] VGND VGND VPWR VPWR net185 sky130_fd_sc_hd__dlygate4sd3_1
XTAP_TAPCELL_ROW_3_226 VGND VPWR sky130_fd_sc_hd__tapvpwrvgnd_1
XFILLER_28_105 VGND VGND VPWR VPWR sky130_fd_sc_hd__fill_2
X_2387_ u_parser.u_decoder.index\[3\] u_parser.u_decoder.index\[2\] VGND VGND VPWR
+ VPWR _1141_ sky130_fd_sc_hd__nand2b_1
XFILLER_68_241 VGND VGND VPWR VPWR sky130_fd_sc_hd__decap_3
X_3008_ net27 net231 _1505_ VGND VGND VPWR VPWR _0569_ sky130_fd_sc_hd__mux2_1
XFILLER_45_39 VPWR VGND VPWR VGND sky130_ef_sc_hd__decap_12
XFILLER_71_439 VGND VGND VPWR VPWR sky130_fd_sc_hd__decap_8
XTAP_TAPCELL_ROW_82_979 VGND VPWR sky130_fd_sc_hd__tapvpwrvgnd_1
XTAP_TAPCELL_ROW_19_380 VGND VPWR sky130_fd_sc_hd__tapvpwrvgnd_1
XFILLER_24_377 VPWR VGND VPWR VGND sky130_ef_sc_hd__decap_12
XFILLER_61_27 VPWR VGND VPWR VGND sky130_ef_sc_hd__decap_12
XFILLER_47_458 VGND VGND VPWR VPWR sky130_fd_sc_hd__decap_6
XFILLER_74_233 VGND VGND VPWR VPWR sky130_fd_sc_hd__decap_6
XTAP_TAPCELL_ROW_45_626 VGND VPWR sky130_fd_sc_hd__tapvpwrvgnd_1
XFILLER_35_94 VGND VGND VPWR VPWR sky130_fd_sc_hd__decap_6
XFILLER_42_141 VGND VGND VPWR VPWR sky130_fd_sc_hd__decap_8
XFILLER_51_93 VPWR VGND VPWR VGND sky130_ef_sc_hd__decap_12
X_2310_ _0682_ _1110_ _1113_ _1114_ VGND VGND VPWR VPWR _1115_ sky130_fd_sc_hd__a22o_1
XPHY_EDGE_ROW_29_Left_123 VGND VGND VPWR VPWR sky130_fd_sc_hd__decap_3
X_3290_ clknet_leaf_4_clk _0126_ VGND VGND VPWR VPWR u_tx_fifo.mem\[5\]\[1\] sky130_fd_sc_hd__dfxtp_1
XFILLER_2_281 VGND VGND VPWR VPWR sky130_fd_sc_hd__fill_2
X_2241_ _0946_ _0961_ VGND VGND VPWR VPWR _1067_ sky130_fd_sc_hd__nor2_4
X_2172_ _1041_ _1046_ VGND VGND VPWR VPWR _1047_ sky130_fd_sc_hd__xnor2_2
XFILLER_18_3 VGND VGND VPWR VPWR sky130_fd_sc_hd__decap_8
XFILLER_93_553 VGND VGND VPWR VPWR sky130_fd_sc_hd__fill_2
XFILLER_38_458 VGND VGND VPWR VPWR sky130_fd_sc_hd__fill_2
XFILLER_18_182 VPWR VGND VPWR VGND sky130_ef_sc_hd__decap_12
XFILLER_80_269 VGND VGND VPWR VPWR sky130_fd_sc_hd__fill_1
XTAP_TAPCELL_ROW_16_350 VGND VPWR sky130_fd_sc_hd__tapvpwrvgnd_1
XPHY_EDGE_ROW_38_Left_132 VGND VGND VPWR VPWR sky130_fd_sc_hd__decap_3
XFILLER_61_461 VPWR VGND VPWR VGND sky130_ef_sc_hd__decap_12
XFILLER_21_369 VPWR VGND VPWR VGND sky130_ef_sc_hd__decap_12
X_1956_ net286 net85 _0945_ VGND VGND VPWR VPWR _0077_ sky130_fd_sc_hd__mux2_1
X_1887_ u_parser.u_packet_encoder.tag_latched\[18\] _0899_ _0900_ u_parser.u_packet_encoder.tag_latched\[26\]
+ _0914_ VGND VGND VPWR VPWR _0915_ sky130_fd_sc_hd__a221o_1
X_3626_ clknet_leaf_40_clk _0453_ net107 VGND VGND VPWR VPWR u_parser.u_decoder.ascii_buf\[1\]\[5\]
+ sky130_fd_sc_hd__dfrtp_1
XPHY_EDGE_ROW_47_Left_141 VGND VGND VPWR VPWR sky130_fd_sc_hd__decap_3
X_3557_ clknet_leaf_35_clk _0384_ net131 VGND VGND VPWR VPWR u_parser.u_decoder.decoded_checksum_calc\[0\]
+ sky130_fd_sc_hd__dfrtp_1
X_2508_ u_parser.u_decoder.ascii_buf\[7\]\[4\] u_parser.u_decoder.ascii_buf\[7\]\[5\]
+ VGND VGND VPWR VPWR _1223_ sky130_fd_sc_hd__nand2_1
X_3488_ clknet_leaf_43_clk _0315_ net111 VGND VGND VPWR VPWR u_parser.u_decoder.ascii_buf\[5\]\[2\]
+ sky130_fd_sc_hd__dfrtp_1
X_2439_ u_parser.u_decoder.timeout_count\[9\] u_parser.u_decoder.timeout_count\[8\]
+ _1168_ VGND VGND VPWR VPWR _1172_ sky130_fd_sc_hd__and3_1
XFILLER_56_27 VGND VGND VPWR VPWR sky130_fd_sc_hd__fill_1
XFILLER_84_553 VGND VGND VPWR VPWR sky130_fd_sc_hd__fill_2
XFILLER_29_458 VGND VGND VPWR VPWR sky130_fd_sc_hd__decap_6
XPHY_EDGE_ROW_56_Left_150 VGND VGND VPWR VPWR sky130_fd_sc_hd__decap_3
XFILLER_71_225 VGND VGND VPWR VPWR sky130_fd_sc_hd__fill_2
XFILLER_72_15 VPWR VGND VPWR VGND sky130_ef_sc_hd__decap_12
XFILLER_52_483 VGND VGND VPWR VPWR sky130_fd_sc_hd__fill_1
XFILLER_8_318 VGND VGND VPWR VPWR sky130_fd_sc_hd__fill_1
XTAP_TAPCELL_ROW_50_673 VGND VPWR sky130_fd_sc_hd__tapvpwrvgnd_1
XFILLER_4_513 VPWR VGND VPWR VGND sky130_ef_sc_hd__decap_12
XFILLER_21_74 VGND VGND VPWR VPWR sky130_fd_sc_hd__decap_6
XFILLER_79_303 VGND VGND VPWR VPWR sky130_fd_sc_hd__decap_3
XFILLER_79_347 VGND VGND VPWR VPWR sky130_fd_sc_hd__decap_4
XFILLER_47_255 VPWR VGND VPWR VGND sky130_ef_sc_hd__decap_12
XTAP_TAPCELL_ROW_58_751 VGND VPWR sky130_fd_sc_hd__tapvpwrvgnd_1
XFILLER_90_501 VPWR VGND VPWR VGND sky130_ef_sc_hd__decap_12
XFILLER_35_417 VGND VGND VPWR VPWR sky130_fd_sc_hd__decap_8
XFILLER_90_545 VGND VGND VPWR VPWR sky130_fd_sc_hd__decap_8
XFILLER_62_269 VGND VGND VPWR VPWR sky130_fd_sc_hd__decap_3
XFILLER_30_133 VGND VGND VPWR VPWR sky130_fd_sc_hd__decap_6
X_1810_ net555 _0862_ VGND VGND VPWR VPWR _0014_ sky130_fd_sc_hd__xnor2_1
X_2790_ _1143_ _1407_ VGND VGND VPWR VPWR _1409_ sky130_fd_sc_hd__nor2_2
X_1741_ u_parser.u_decoder.decoded_checksum_calc\[5\] u_parser.u_decoder.decoded_checksum_rx\[5\]
+ VGND VGND VPWR VPWR _0807_ sky130_fd_sc_hd__nand2b_1
Xhold307 u_parser.u_packet_encoder.tag_latched\[11\] VGND VGND VPWR VPWR net463 sky130_fd_sc_hd__dlygate4sd3_1
X_1672_ net58 _0738_ u_rx_fifo.rd_ptr\[3\] VGND VGND VPWR VPWR _0739_ sky130_fd_sc_hd__o21a_1
Xhold329 u_uart_rx.low_count\[19\] VGND VGND VPWR VPWR net485 sky130_fd_sc_hd__dlygate4sd3_1
Xhold318 u_uart_tx.tx_data\[7\] VGND VGND VPWR VPWR net474 sky130_fd_sc_hd__dlygate4sd3_1
X_3411_ clknet_leaf_58_clk _0244_ VGND VGND VPWR VPWR u_tx_fifo.mem\[2\]\[3\] sky130_fd_sc_hd__dfxtp_1
X_3342_ clknet_leaf_4_clk _0175_ VGND VGND VPWR VPWR u_tx_fifo.mem\[3\]\[2\] sky130_fd_sc_hd__dfxtp_1
XTAP_TAPCELL_ROW_90_1057 VGND VPWR sky130_fd_sc_hd__tapvpwrvgnd_1
X_3273_ clknet_leaf_62_clk _0109_ VGND VGND VPWR VPWR u_tx_fifo.mem\[12\]\[0\] sky130_fd_sc_hd__dfxtp_1
X_2224_ tag_raw\[31\] net541 net53 VGND VGND VPWR VPWR _0228_ sky130_fd_sc_hd__mux2_1
XFILLER_38_211 VGND VGND VPWR VPWR sky130_fd_sc_hd__fill_1
X_2155_ _1016_ _1031_ VGND VGND VPWR VPWR _1032_ sky130_fd_sc_hd__xnor2_2
XFILLER_66_531 VGND VGND VPWR VPWR sky130_fd_sc_hd__fill_1
XFILLER_66_553 VGND VGND VPWR VPWR sky130_fd_sc_hd__fill_2
XFILLER_93_361 VGND VGND VPWR VPWR sky130_fd_sc_hd__decap_3
XFILLER_81_501 VGND VGND VPWR VPWR sky130_fd_sc_hd__decap_3
XFILLER_53_214 VGND VGND VPWR VPWR sky130_fd_sc_hd__fill_2
X_2086_ _0743_ net592 _0967_ VGND VGND VPWR VPWR _0185_ sky130_fd_sc_hd__mux2_1
XFILLER_34_450 VGND VGND VPWR VPWR sky130_fd_sc_hd__decap_4
XFILLER_42_29 VPWR VGND VPWR VGND sky130_ef_sc_hd__decap_12
X_2988_ _0668_ net423 VGND VGND VPWR VPWR _0556_ sky130_fd_sc_hd__and2_1
X_1939_ net365 net82 _0943_ VGND VGND VPWR VPWR _0062_ sky130_fd_sc_hd__mux2_1
X_3609_ clknet_leaf_37_clk _0436_ net129 VGND VGND VPWR VPWR u_parser.u_decoder.decoded_checksum_rx\[4\]
+ sky130_fd_sc_hd__dfrtp_1
XFILLER_1_505 VPWR VGND VPWR VGND sky130_ef_sc_hd__decap_12
XFILLER_67_15 VPWR VGND VPWR VGND sky130_ef_sc_hd__decap_12
XFILLER_57_531 VPWR VGND VPWR VGND sky130_ef_sc_hd__decap_12
XFILLER_44_247 VGND VGND VPWR VPWR sky130_fd_sc_hd__decap_4
XTAP_TAPCELL_ROW_55_721 VGND VPWR sky130_fd_sc_hd__tapvpwrvgnd_1
XFILLER_72_545 VGND VGND VPWR VPWR sky130_fd_sc_hd__decap_8
XTAP_TAPCELL_ROW_27_456 VGND VPWR sky130_fd_sc_hd__tapvpwrvgnd_1
XFILLER_16_85 VGND VGND VPWR VPWR sky130_fd_sc_hd__fill_2
XPHY_EDGE_ROW_11_Right_11 VGND VGND VPWR VPWR sky130_fd_sc_hd__decap_3
XTAP_TAPCELL_ROW_10_301 VGND VPWR sky130_fd_sc_hd__tapvpwrvgnd_1
XFILLER_4_365 VPWR VGND VPWR VGND sky130_ef_sc_hd__decap_12
XPHY_EDGE_ROW_20_Right_20 VGND VGND VPWR VPWR sky130_fd_sc_hd__decap_3
XFILLER_75_361 VGND VGND VPWR VPWR sky130_fd_sc_hd__fill_2
XFILLER_35_225 VGND VGND VPWR VPWR sky130_fd_sc_hd__decap_8
X_2911_ u_uart_tx.clk_count\[7\] u_uart_tx.clk_count\[6\] _1450_ VGND VGND VPWR VPWR
+ _1454_ sky130_fd_sc_hd__and3_1
XTAP_TAPCELL_ROW_61_779 VGND VPWR sky130_fd_sc_hd__tapvpwrvgnd_1
XFILLER_85_3 VPWR VGND VPWR VGND sky130_ef_sc_hd__decap_12
X_2842_ _1424_ _1425_ VGND VGND VPWR VPWR _1426_ sky130_fd_sc_hd__nand2_1
XFILLER_31_486 VGND VGND VPWR VPWR sky130_fd_sc_hd__decap_8
X_2773_ u_parser.u_decoder.ascii_buf\[10\]\[1\] _1399_ VGND VGND VPWR VPWR _1403_
+ sky130_fd_sc_hd__xor2_1
X_1724_ u_parser.u_decoder.timeout_count\[15\] u_parser.u_decoder.timeout_count\[17\]
+ u_parser.u_decoder.timeout_count\[16\] VGND VGND VPWR VPWR _0791_ sky130_fd_sc_hd__and3_1
Xhold126 u_rx_fifo.mem\[2\]\[0\] VGND VGND VPWR VPWR net282 sky130_fd_sc_hd__dlygate4sd3_1
Xhold115 u_rx_fifo.mem\[12\]\[2\] VGND VGND VPWR VPWR net271 sky130_fd_sc_hd__dlygate4sd3_1
Xhold104 u_rx_fifo.mem\[9\]\[1\] VGND VGND VPWR VPWR net260 sky130_fd_sc_hd__dlygate4sd3_1
Xhold159 u_tx_fifo.mem\[1\]\[4\] VGND VGND VPWR VPWR net315 sky130_fd_sc_hd__dlygate4sd3_1
Xhold148 u_tx_fifo.mem\[15\]\[2\] VGND VGND VPWR VPWR net304 sky130_fd_sc_hd__dlygate4sd3_1
Xhold137 u_tx_fifo.mem\[6\]\[0\] VGND VGND VPWR VPWR net293 sky130_fd_sc_hd__dlygate4sd3_1
X_1655_ net58 _0719_ u_rx_fifo.rd_ptr\[3\] VGND VGND VPWR VPWR _0722_ sky130_fd_sc_hd__o21a_1
X_3325_ clknet_leaf_9_clk _0161_ VGND VGND VPWR VPWR u_rx_fifo.mem\[12\]\[4\] sky130_fd_sc_hd__dfxtp_1
X_3256_ clknet_leaf_1_clk _0092_ VGND VGND VPWR VPWR u_tx_fifo.mem\[6\]\[7\] sky130_fd_sc_hd__dfxtp_1
XFILLER_58_317 VPWR VGND VPWR VGND sky130_ef_sc_hd__decap_12
X_2207_ tag_raw\[14\] net429 net54 VGND VGND VPWR VPWR _0211_ sky130_fd_sc_hd__mux2_1
XTAP_TAPCELL_ROW_69_857 VGND VPWR sky130_fd_sc_hd__tapvpwrvgnd_1
X_3187_ clknet_leaf_13_clk _0023_ VGND VGND VPWR VPWR u_rx_fifo.mem\[6\]\[2\] sky130_fd_sc_hd__dfxtp_1
X_2138_ _1007_ _1015_ VGND VGND VPWR VPWR _1016_ sky130_fd_sc_hd__xnor2_2
XFILLER_14_409 VGND VGND VPWR VPWR sky130_fd_sc_hd__decap_8
X_2069_ net28 net353 _0962_ VGND VGND VPWR VPWR _0173_ sky130_fd_sc_hd__mux2_1
XTAP_TAPCELL_ROW_24_426 VGND VPWR sky130_fd_sc_hd__tapvpwrvgnd_1
XFILLER_53_39 VPWR VGND VPWR VGND sky130_ef_sc_hd__decap_12
XFILLER_1_335 VGND VGND VPWR VPWR sky130_fd_sc_hd__fill_1
XFILLER_64_309 VGND VGND VPWR VPWR sky130_fd_sc_hd__decap_4
XFILLER_17_225 VGND VGND VPWR VPWR sky130_fd_sc_hd__decap_3
XFILLER_40_250 VGND VGND VPWR VPWR sky130_fd_sc_hd__fill_2
XFILLER_40_261 VGND VGND VPWR VPWR sky130_fd_sc_hd__decap_4
XFILLER_43_94 VGND VGND VPWR VPWR sky130_fd_sc_hd__decap_8
X_3110_ net535 net83 _0845_ VGND VGND VPWR VPWR _0618_ sky130_fd_sc_hd__mux2_1
X_3041_ _1514_ _1513_ u_uart_rx.sample_phase\[0\] VGND VGND VPWR VPWR _0593_ sky130_fd_sc_hd__mux2_1
XFILLER_82_106 VGND VGND VPWR VPWR sky130_fd_sc_hd__decap_4
XFILLER_36_501 VGND VGND VPWR VPWR sky130_fd_sc_hd__fill_1
XFILLER_48_361 VGND VGND VPWR VPWR sky130_fd_sc_hd__decap_3
XTAP_TAPCELL_ROW_66_827 VGND VPWR sky130_fd_sc_hd__tapvpwrvgnd_1
XFILLER_36_545 VGND VGND VPWR VPWR sky130_fd_sc_hd__decap_8
XFILLER_48_383 VGND VGND VPWR VPWR sky130_fd_sc_hd__fill_1
XFILLER_63_364 VGND VGND VPWR VPWR sky130_fd_sc_hd__fill_2
XFILLER_51_548 VGND VGND VPWR VPWR sky130_fd_sc_hd__decap_6
Xclkbuf_3_2__f_clk clknet_0_clk VGND VGND VPWR VPWR clknet_3_2__leaf_clk sky130_fd_sc_hd__clkbuf_16
X_2825_ _0813_ _1142_ net602 VGND VGND VPWR VPWR _0479_ sky130_fd_sc_hd__o21a_1
X_2756_ _0677_ net12 VGND VGND VPWR VPWR _1389_ sky130_fd_sc_hd__nor2_1
X_2687_ _1220_ _1278_ VGND VGND VPWR VPWR _1364_ sky130_fd_sc_hd__xor2_1
X_1707_ u_rx_fifo.mem\[12\]\[5\] u_rx_fifo.mem\[13\]\[5\] u_rx_fifo.mem\[14\]\[5\]
+ u_rx_fifo.mem\[15\]\[5\] net152 net148 VGND VGND VPWR VPWR _0774_ sky130_fd_sc_hd__mux4_1
X_1638_ net544 _0698_ _0704_ VGND VGND VPWR VPWR _0007_ sky130_fd_sc_hd__a21o_1
XFILLER_86_412 VGND VGND VPWR VPWR sky130_fd_sc_hd__fill_1
XFILLER_86_445 VPWR VGND VPWR VGND sky130_ef_sc_hd__decap_12
X_3308_ clknet_leaf_62_clk _0144_ VGND VGND VPWR VPWR u_tx_fifo.mem\[13\]\[3\] sky130_fd_sc_hd__dfxtp_1
X_3239_ clknet_leaf_15_clk _0075_ VGND VGND VPWR VPWR u_rx_fifo.mem\[5\]\[6\] sky130_fd_sc_hd__dfxtp_1
XFILLER_39_361 VGND VGND VPWR VPWR sky130_fd_sc_hd__decap_6
XFILLER_64_27 VGND VGND VPWR VPWR sky130_fd_sc_hd__fill_1
XTAP_TAPCELL_ROW_37_551 VGND VPWR sky130_fd_sc_hd__tapvpwrvgnd_1
XFILLER_66_191 VGND VGND VPWR VPWR sky130_fd_sc_hd__decap_4
XFILLER_14_217 VGND VGND VPWR VPWR sky130_fd_sc_hd__decap_3
XFILLER_14_239 VGND VGND VPWR VPWR sky130_fd_sc_hd__fill_1
Xfanout21 net22 VGND VGND VPWR VPWR net21 sky130_fd_sc_hd__clkbuf_2
Xfanout10 net14 VGND VGND VPWR VPWR net10 sky130_fd_sc_hd__clkbuf_4
XFILLER_80_37 VGND VGND VPWR VPWR sky130_fd_sc_hd__decap_3
XFILLER_80_15 VPWR VGND VPWR VGND sky130_ef_sc_hd__decap_12
Xfanout65 u_tx_fifo.rd_ptr\[1\] VGND VGND VPWR VPWR net65 sky130_fd_sc_hd__buf_2
Xfanout32 _0927_ VGND VGND VPWR VPWR net32 sky130_fd_sc_hd__clkbuf_2
Xfanout54 net57 VGND VGND VPWR VPWR net54 sky130_fd_sc_hd__buf_2
Xfanout43 _0743_ VGND VGND VPWR VPWR net43 sky130_fd_sc_hd__clkbuf_4
Xfanout76 rx_fifo_in_data\[4\] VGND VGND VPWR VPWR net76 sky130_fd_sc_hd__buf_2
XFILLER_13_20 VGND VGND VPWR VPWR sky130_fd_sc_hd__decap_6
XFILLER_10_412 VGND VGND VPWR VPWR sky130_fd_sc_hd__decap_8
Xfanout98 net101 VGND VGND VPWR VPWR net98 sky130_fd_sc_hd__clkbuf_4
Xfanout87 rdm_rx_sync VGND VGND VPWR VPWR net87 sky130_fd_sc_hd__buf_2
XFILLER_10_445 VPWR VGND VPWR VGND sky130_ef_sc_hd__decap_12
XFILLER_10_489 VPWR VGND VPWR VGND sky130_ef_sc_hd__decap_12
XFILLER_89_57 VGND VGND VPWR VPWR sky130_fd_sc_hd__decap_6
Xhold490 u_tx_fifo.level\[2\] VGND VGND VPWR VPWR net646 sky130_fd_sc_hd__dlygate4sd3_1
XFILLER_1_132 VGND VGND VPWR VPWR sky130_fd_sc_hd__decap_3
XTAP_TAPCELL_ROW_9_287 VGND VPWR sky130_fd_sc_hd__tapvpwrvgnd_1
XFILLER_77_445 VGND VGND VPWR VPWR sky130_fd_sc_hd__decap_3
XFILLER_49_125 VPWR VGND VPWR VGND sky130_ef_sc_hd__decap_12
XFILLER_92_404 VPWR VGND VPWR VGND sky130_ef_sc_hd__decap_12
XFILLER_92_459 VPWR VGND VPWR VGND sky130_ef_sc_hd__decap_12
XFILLER_18_523 VGND VGND VPWR VPWR sky130_fd_sc_hd__decap_8
XFILLER_64_139 VGND VGND VPWR VPWR sky130_fd_sc_hd__fill_1
XFILLER_18_545 VGND VGND VPWR VPWR sky130_fd_sc_hd__decap_8
XFILLER_45_331 VGND VGND VPWR VPWR sky130_fd_sc_hd__decap_4
XFILLER_60_356 VGND VGND VPWR VPWR sky130_fd_sc_hd__decap_8
XTAP_TAPCELL_ROW_71_874 VGND VPWR sky130_fd_sc_hd__tapvpwrvgnd_1
Xclkload24 clknet_leaf_47_clk VGND VGND VPWR VPWR clkload24/Y sky130_fd_sc_hd__clkinv_8
XFILLER_9_298 VGND VGND VPWR VPWR sky130_fd_sc_hd__decap_4
Xclkload13 clknet_leaf_64_clk VGND VGND VPWR VPWR clkload13/Y sky130_fd_sc_hd__inv_6
X_3590_ clknet_leaf_44_clk _0417_ net111 VGND VGND VPWR VPWR u_parser.u_decoder.ascii_buf\[9\]\[1\]
+ sky130_fd_sc_hd__dfrtp_1
Xclkload35 clknet_leaf_43_clk VGND VGND VPWR VPWR clkload35/X sky130_fd_sc_hd__clkbuf_8
X_2610_ _1302_ _1303_ VGND VGND VPWR VPWR _1304_ sky130_fd_sc_hd__nor2_1
Xclkload46 clknet_leaf_15_clk VGND VGND VPWR VPWR clkload46/Y sky130_fd_sc_hd__inv_6
X_2541_ net442 _1249_ net8 VGND VGND VPWR VPWR _0358_ sky130_fd_sc_hd__mux2_1
Xclkload57 clknet_leaf_25_clk VGND VGND VPWR VPWR clkload57/Y sky130_fd_sc_hd__inv_8
XPHY_EDGE_ROW_10_Left_104 VGND VGND VPWR VPWR sky130_fd_sc_hd__decap_3
X_2472_ u_parser.u_decoder.ascii_buf\[9\]\[3\] _1192_ _1193_ u_parser.u_decoder.ascii_buf\[9\]\[7\]
+ u_parser.u_decoder.ascii_buf\[9\]\[6\] VGND VGND VPWR VPWR _1195_ sky130_fd_sc_hd__a2111o_1
XFILLER_48_3 VPWR VGND VPWR VGND sky130_ef_sc_hd__decap_12
XTAP_TAPCELL_ROW_79_952 VGND VPWR sky130_fd_sc_hd__tapvpwrvgnd_1
XFILLER_28_309 VGND VGND VPWR VPWR sky130_fd_sc_hd__fill_2
XFILLER_68_489 VPWR VGND VPWR VGND sky130_ef_sc_hd__decap_12
XTAP_TAPCELL_ROW_87_1029 VGND VPWR sky130_fd_sc_hd__tapvpwrvgnd_1
XFILLER_55_117 VGND VGND VPWR VPWR sky130_fd_sc_hd__fill_1
X_3024_ net70 net274 _1506_ VGND VGND VPWR VPWR _0584_ sky130_fd_sc_hd__mux2_1
XTAP_TAPCELL_ROW_34_521 VGND VPWR sky130_fd_sc_hd__tapvpwrvgnd_1
XFILLER_51_334 VGND VGND VPWR VPWR sky130_fd_sc_hd__fill_2
XFILLER_51_389 VGND VGND VPWR VPWR sky130_fd_sc_hd__decap_3
Xclkload7 clknet_leaf_0_clk VGND VGND VPWR VPWR clkload7/Y sky130_fd_sc_hd__inv_6
XFILLER_50_29 VPWR VGND VPWR VGND sky130_ef_sc_hd__decap_12
X_3788_ clknet_leaf_28_clk _0606_ net139 VGND VGND VPWR VPWR u_uart_rx.sample_div_count\[8\]
+ sky130_fd_sc_hd__dfrtp_1
X_2808_ _0964_ _1407_ VGND VGND VPWR VPWR _1411_ sky130_fd_sc_hd__nor2_2
X_2739_ net35 net607 _1376_ VGND VGND VPWR VPWR _0429_ sky130_fd_sc_hd__mux2_1
XFILLER_59_27 VPWR VGND VPWR VGND sky130_ef_sc_hd__decap_12
XTAP_TAPCELL_ROW_6_257 VGND VPWR sky130_fd_sc_hd__tapvpwrvgnd_1
XFILLER_59_445 VGND VGND VPWR VPWR sky130_fd_sc_hd__decap_3
XFILLER_75_15 VPWR VGND VPWR VGND sky130_ef_sc_hd__decap_12
XFILLER_46_139 VGND VGND VPWR VPWR sky130_fd_sc_hd__fill_1
XFILLER_24_85 VGND VGND VPWR VPWR sky130_fd_sc_hd__decap_4
XFILLER_10_253 VGND VGND VPWR VPWR sky130_fd_sc_hd__decap_3
XFILLER_6_213 VGND VGND VPWR VPWR sky130_fd_sc_hd__fill_1
XTAP_TAPCELL_ROW_40_579 VGND VPWR sky130_fd_sc_hd__tapvpwrvgnd_1
XFILLER_49_93 VPWR VGND VPWR VGND sky130_ef_sc_hd__decap_12
XFILLER_92_201 VGND VGND VPWR VPWR sky130_fd_sc_hd__decap_6
XTAP_TAPCELL_ROW_76_922 VGND VPWR sky130_fd_sc_hd__tapvpwrvgnd_1
XFILLER_18_342 VGND VGND VPWR VPWR sky130_fd_sc_hd__fill_1
XTAP_TAPCELL_ROW_48_657 VGND VPWR sky130_fd_sc_hd__tapvpwrvgnd_1
X_1972_ net230 net19 _0947_ VGND VGND VPWR VPWR _0091_ sky130_fd_sc_hd__mux2_1
XFILLER_60_197 VGND VGND VPWR VPWR sky130_fd_sc_hd__fill_1
X_3711_ clknet_leaf_32_clk _0535_ net143 VGND VGND VPWR VPWR u_uart_rx.low_count\[1\]
+ sky130_fd_sc_hd__dfrtp_1
X_3642_ clknet_leaf_35_clk _0469_ net132 VGND VGND VPWR VPWR u_parser.u_decoder.ascii_buf\[3\]\[5\]
+ sky130_fd_sc_hd__dfrtp_1
XPHY_EDGE_ROW_49_Right_49 VGND VGND VPWR VPWR sky130_fd_sc_hd__decap_3
X_3573_ clknet_leaf_24_clk _0400_ net128 VGND VGND VPWR VPWR u_parser.u_decoder.ascii_buf\[10\]\[0\]
+ sky130_fd_sc_hd__dfrtp_1
X_2524_ u_parser.u_decoder.ascii_buf\[7\]\[3\] _1225_ _1229_ VGND VGND VPWR VPWR _1236_
+ sky130_fd_sc_hd__a21o_1
XTAP_TAPCELL_ROW_93_1099 VGND VPWR sky130_fd_sc_hd__tapvpwrvgnd_1
XTAP_TAPCELL_ROW_93_1088 VGND VPWR sky130_fd_sc_hd__tapvpwrvgnd_1
X_2455_ _1152_ _1163_ _1181_ u_parser.u_decoder.timeout_count\[14\] VGND VGND VPWR
+ VPWR _1183_ sky130_fd_sc_hd__a31o_1
Xhold19 u_rx_fifo.mem\[0\]\[5\] VGND VGND VPWR VPWR net175 sky130_fd_sc_hd__dlygate4sd3_1
X_2386_ tag_raw\[39\] net488 net15 VGND VGND VPWR VPWR _0312_ sky130_fd_sc_hd__mux2_1
XFILLER_68_253 VGND VGND VPWR VPWR sky130_fd_sc_hd__fill_2
XTAP_TAPCELL_ROW_3_227 VGND VPWR sky130_fd_sc_hd__tapvpwrvgnd_1
XFILLER_28_139 VGND VGND VPWR VPWR sky130_fd_sc_hd__fill_1
XFILLER_68_275 VGND VGND VPWR VPWR sky130_fd_sc_hd__decap_6
XPHY_EDGE_ROW_58_Right_58 VGND VGND VPWR VPWR sky130_fd_sc_hd__decap_3
X_3007_ u_tx_fifo.wr_ptr\[2\] u_tx_fifo.wr_ptr\[3\] _0889_ VGND VGND VPWR VPWR _1505_
+ sky130_fd_sc_hd__nand3_4
XTAP_TAPCELL_ROW_19_381 VGND VPWR sky130_fd_sc_hd__tapvpwrvgnd_1
XFILLER_24_345 VGND VGND VPWR VPWR sky130_fd_sc_hd__decap_8
XFILLER_24_389 VGND VGND VPWR VPWR sky130_fd_sc_hd__fill_2
XFILLER_61_39 VPWR VGND VPWR VGND sky130_ef_sc_hd__decap_12
XPHY_EDGE_ROW_67_Right_67 VGND VGND VPWR VPWR sky130_fd_sc_hd__decap_3
XPHY_EDGE_ROW_76_Right_76 VGND VGND VPWR VPWR sky130_fd_sc_hd__decap_3
XTAP_TAPCELL_ROW_45_627 VGND VPWR sky130_fd_sc_hd__tapvpwrvgnd_1
XFILLER_15_356 VGND VGND VPWR VPWR sky130_fd_sc_hd__decap_8
XPHY_EDGE_ROW_85_Right_85 VGND VGND VPWR VPWR sky130_fd_sc_hd__decap_3
X_2240_ _0881_ _0894_ _1065_ _1066_ VGND VGND VPWR VPWR _0240_ sky130_fd_sc_hd__a22o_1
X_2171_ _1023_ _1045_ VGND VGND VPWR VPWR _1046_ sky130_fd_sc_hd__xnor2_2
XFILLER_76_80 VGND VGND VPWR VPWR sky130_fd_sc_hd__decap_4
XFILLER_65_278 VGND VGND VPWR VPWR sky130_fd_sc_hd__fill_2
XFILLER_18_194 VGND VGND VPWR VPWR sky130_fd_sc_hd__fill_2
XFILLER_61_440 VGND VGND VPWR VPWR sky130_fd_sc_hd__decap_8
XTAP_TAPCELL_ROW_16_351 VGND VPWR sky130_fd_sc_hd__tapvpwrvgnd_1
XFILLER_61_473 VGND VGND VPWR VPWR sky130_fd_sc_hd__decap_4
X_1955_ _0875_ _0884_ VGND VGND VPWR VPWR _0945_ sky130_fd_sc_hd__nor2_4
X_1886_ u_parser.u_packet_encoder.tag_latched\[10\] _0894_ _0902_ u_parser.u_packet_encoder.tag_latched\[2\]
+ VGND VGND VPWR VPWR _0914_ sky130_fd_sc_hd__a22o_1
X_3625_ clknet_leaf_38_clk _0452_ net130 VGND VGND VPWR VPWR u_parser.u_decoder.ascii_buf\[1\]\[4\]
+ sky130_fd_sc_hd__dfrtp_1
X_3556_ clknet_leaf_23_clk _0383_ net117 VGND VGND VPWR VPWR u_parser.u_decoder.decoded_payload\[39\]
+ sky130_fd_sc_hd__dfrtp_1
X_2507_ u_parser.u_decoder.ascii_buf\[7\]\[1\] u_parser.u_decoder.ascii_buf\[7\]\[2\]
+ u_parser.u_decoder.ascii_buf\[7\]\[3\] VGND VGND VPWR VPWR _1222_ sky130_fd_sc_hd__o21a_1
X_3487_ clknet_leaf_43_clk _0314_ net111 VGND VGND VPWR VPWR u_parser.u_decoder.ascii_buf\[5\]\[1\]
+ sky130_fd_sc_hd__dfrtp_1
X_2438_ u_parser.u_decoder.timeout_count\[8\] _1168_ u_parser.u_decoder.timeout_count\[9\]
+ VGND VGND VPWR VPWR _1171_ sky130_fd_sc_hd__a21o_1
X_2369_ tag_raw\[22\] net443 net16 VGND VGND VPWR VPWR _0295_ sky130_fd_sc_hd__mux2_1
XFILLER_56_201 VGND VGND VPWR VPWR sky130_fd_sc_hd__fill_1
XFILLER_44_418 VGND VGND VPWR VPWR sky130_fd_sc_hd__fill_2
XFILLER_56_267 VGND VGND VPWR VPWR sky130_fd_sc_hd__fill_2
XFILLER_72_27 VGND VGND VPWR VPWR sky130_fd_sc_hd__fill_1
XFILLER_12_315 VGND VGND VPWR VPWR sky130_fd_sc_hd__decap_6
XFILLER_24_197 VGND VGND VPWR VPWR sky130_fd_sc_hd__fill_2
XTAP_TAPCELL_ROW_50_674 VGND VPWR sky130_fd_sc_hd__tapvpwrvgnd_1
XFILLER_4_525 VGND VGND VPWR VPWR sky130_fd_sc_hd__decap_6
XFILLER_79_337 VGND VGND VPWR VPWR sky130_fd_sc_hd__decap_4
XTAP_TAPCELL_ROW_58_752 VGND VPWR sky130_fd_sc_hd__tapvpwrvgnd_1
XFILLER_90_513 VPWR VGND VPWR VGND sky130_ef_sc_hd__decap_12
XFILLER_47_267 VPWR VGND VPWR VGND sky130_ef_sc_hd__decap_12
XFILLER_46_83 VGND VGND VPWR VPWR sky130_fd_sc_hd__fill_1
XFILLER_62_259 VGND VGND VPWR VPWR sky130_fd_sc_hd__fill_1
XTAP_TAPCELL_ROW_13_321 VGND VPWR sky130_fd_sc_hd__tapvpwrvgnd_1
X_1740_ u_parser.u_decoder.decoded_checksum_calc\[7\] u_parser.u_decoder.decoded_checksum_rx\[7\]
+ VGND VGND VPWR VPWR _0806_ sky130_fd_sc_hd__nand2b_1
Xhold308 u_uart_rx.low_count\[23\] VGND VGND VPWR VPWR net464 sky130_fd_sc_hd__dlygate4sd3_1
XFILLER_7_77 VGND VGND VPWR VPWR sky130_fd_sc_hd__fill_1
X_1671_ u_rx_fifo.mem\[12\]\[6\] u_rx_fifo.mem\[13\]\[6\] u_rx_fifo.mem\[14\]\[6\]
+ u_rx_fifo.mem\[15\]\[6\] net152 net148 VGND VGND VPWR VPWR _0738_ sky130_fd_sc_hd__mux4_1
Xhold319 u_parser.u_decoder.decoded_payload\[30\] VGND VGND VPWR VPWR net475 sky130_fd_sc_hd__dlygate4sd3_1
X_3410_ clknet_leaf_4_clk _0243_ VGND VGND VPWR VPWR u_tx_fifo.mem\[2\]\[2\] sky130_fd_sc_hd__dfxtp_1
X_3341_ clknet_leaf_7_clk _0174_ VGND VGND VPWR VPWR u_tx_fifo.mem\[3\]\[1\] sky130_fd_sc_hd__dfxtp_1
XTAP_TAPCELL_ROW_90_1058 VGND VPWR sky130_fd_sc_hd__tapvpwrvgnd_1
XFILLER_30_3 VPWR VGND VPWR VGND sky130_ef_sc_hd__decap_12
X_3272_ clknet_leaf_12_clk _0108_ VGND VGND VPWR VPWR u_rx_fifo.mem\[11\]\[7\] sky130_fd_sc_hd__dfxtp_1
X_2223_ tag_raw\[30\] net546 net53 VGND VGND VPWR VPWR _0227_ sky130_fd_sc_hd__mux2_1
X_2154_ _1020_ _1030_ VGND VGND VPWR VPWR _1031_ sky130_fd_sc_hd__xnor2_2
X_2085_ net44 u_parser.u_decoder.ascii_buf\[11\]\[3\] _0967_ VGND VGND VPWR VPWR _0184_
+ sky130_fd_sc_hd__mux2_1
X_2987_ _0668_ net421 VGND VGND VPWR VPWR _0555_ sky130_fd_sc_hd__and2_1
X_1938_ net233 net84 _0943_ VGND VGND VPWR VPWR _0061_ sky130_fd_sc_hd__mux2_1
X_1869_ _0893_ _0898_ VGND VGND VPWR VPWR _0899_ sky130_fd_sc_hd__nor2_4
X_3608_ clknet_leaf_36_clk _0435_ net131 VGND VGND VPWR VPWR u_parser.u_decoder.decoded_checksum_rx\[3\]
+ sky130_fd_sc_hd__dfrtp_1
XFILLER_1_517 VPWR VGND VPWR VGND sky130_ef_sc_hd__decap_12
XFILLER_88_101 VGND VGND VPWR VPWR sky130_fd_sc_hd__decap_3
X_3539_ clknet_leaf_56_clk _0366_ net95 VGND VGND VPWR VPWR u_parser.u_decoder.decoded_payload\[22\]
+ sky130_fd_sc_hd__dfrtp_1
XFILLER_67_27 VPWR VGND VPWR VGND sky130_ef_sc_hd__decap_12
XFILLER_57_543 VPWR VGND VPWR VGND sky130_ef_sc_hd__decap_12
XFILLER_83_15 VPWR VGND VPWR VGND sky130_ef_sc_hd__decap_12
XFILLER_44_215 VGND VGND VPWR VPWR sky130_fd_sc_hd__fill_2
XTAP_TAPCELL_ROW_55_722 VGND VPWR sky130_fd_sc_hd__tapvpwrvgnd_1
XFILLER_16_53 VGND VGND VPWR VPWR sky130_fd_sc_hd__decap_8
XTAP_TAPCELL_ROW_27_457 VGND VPWR sky130_fd_sc_hd__tapvpwrvgnd_1
XFILLER_52_281 VGND VGND VPWR VPWR sky130_fd_sc_hd__decap_6
XFILLER_8_138 VGND VGND VPWR VPWR sky130_fd_sc_hd__fill_2
XFILLER_32_63 VGND VGND VPWR VPWR sky130_fd_sc_hd__decap_4
XFILLER_4_333 VGND VGND VPWR VPWR sky130_fd_sc_hd__fill_1
XFILLER_4_377 VPWR VGND VPWR VGND sky130_ef_sc_hd__decap_12
XFILLER_79_134 VGND VGND VPWR VPWR sky130_fd_sc_hd__fill_2
XFILLER_48_521 VGND VGND VPWR VPWR sky130_fd_sc_hd__fill_2
XFILLER_48_554 VGND VGND VPWR VPWR sky130_fd_sc_hd__fill_1
XFILLER_63_502 VGND VGND VPWR VPWR sky130_fd_sc_hd__fill_2
XFILLER_90_321 VGND VGND VPWR VPWR sky130_fd_sc_hd__fill_1
X_2910_ _1452_ _1453_ VGND VGND VPWR VPWR _0523_ sky130_fd_sc_hd__nor2_1
XFILLER_43_281 VGND VGND VPWR VPWR sky130_fd_sc_hd__decap_4
X_2841_ net50 _0882_ _1422_ _1419_ VGND VGND VPWR VPWR _1425_ sky130_fd_sc_hd__or4b_1
XPHY_EDGE_ROW_75_Left_169 VGND VGND VPWR VPWR sky130_fd_sc_hd__decap_3
XFILLER_78_3 VPWR VGND VPWR VGND sky130_ef_sc_hd__decap_12
X_2772_ u_parser.u_decoder.ascii_buf\[10\]\[5\] _1393_ _1394_ _1397_ VGND VGND VPWR
+ VPWR _1402_ sky130_fd_sc_hd__a211o_1
X_1723_ u_parser.u_decoder.timeout_count\[13\] u_parser.u_decoder.timeout_count\[9\]
+ _0789_ u_parser.u_decoder.timeout_count\[14\] VGND VGND VPWR VPWR _0790_ sky130_fd_sc_hd__a211o_1
Xhold105 u_rx_fifo.mem\[0\]\[6\] VGND VGND VPWR VPWR net261 sky130_fd_sc_hd__dlygate4sd3_1
Xhold116 u_rx_fifo.mem\[4\]\[1\] VGND VGND VPWR VPWR net272 sky130_fd_sc_hd__dlygate4sd3_1
Xhold149 u_tx_fifo.mem\[12\]\[0\] VGND VGND VPWR VPWR net305 sky130_fd_sc_hd__dlygate4sd3_1
Xhold138 u_rx_fifo.mem\[15\]\[2\] VGND VGND VPWR VPWR net294 sky130_fd_sc_hd__dlygate4sd3_1
X_1654_ net145 _0720_ VGND VGND VPWR VPWR _0721_ sky130_fd_sc_hd__or2_1
Xhold127 u_rx_fifo.mem\[9\]\[0\] VGND VGND VPWR VPWR net283 sky130_fd_sc_hd__dlygate4sd3_1
X_3324_ clknet_leaf_21_clk _0160_ VGND VGND VPWR VPWR u_rx_fifo.mem\[12\]\[3\] sky130_fd_sc_hd__dfxtp_1
XPHY_EDGE_ROW_84_Left_178 VGND VGND VPWR VPWR sky130_fd_sc_hd__decap_3
X_3255_ clknet_leaf_2_clk _0091_ VGND VGND VPWR VPWR u_tx_fifo.mem\[6\]\[6\] sky130_fd_sc_hd__dfxtp_1
XFILLER_58_329 VPWR VGND VPWR VGND sky130_ef_sc_hd__decap_12
X_2206_ tag_raw\[13\] net431 net54 VGND VGND VPWR VPWR _0210_ sky130_fd_sc_hd__mux2_1
XTAP_TAPCELL_ROW_69_858 VGND VPWR sky130_fd_sc_hd__tapvpwrvgnd_1
X_3186_ clknet_leaf_16_clk _0022_ VGND VGND VPWR VPWR u_rx_fifo.mem\[6\]\[1\] sky130_fd_sc_hd__dfxtp_1
XFILLER_81_310 VGND VGND VPWR VPWR sky130_fd_sc_hd__decap_3
X_2137_ tag_raw\[16\] _1014_ VGND VGND VPWR VPWR _1015_ sky130_fd_sc_hd__xnor2_1
X_2068_ u_tx_fifo.wr_ptr\[2\] u_tx_fifo.wr_ptr\[3\] _0889_ VGND VGND VPWR VPWR _0962_
+ sky130_fd_sc_hd__or3b_4
XTAP_TAPCELL_ROW_24_427 VGND VPWR sky130_fd_sc_hd__tapvpwrvgnd_1
XPHY_EDGE_ROW_93_Left_187 VGND VGND VPWR VPWR sky130_fd_sc_hd__decap_3
XFILLER_22_421 VPWR VGND VPWR VGND sky130_ef_sc_hd__decap_12
XFILLER_78_15 VPWR VGND VPWR VGND sky130_ef_sc_hd__decap_12
XFILLER_57_362 VGND VGND VPWR VPWR sky130_fd_sc_hd__decap_8
XFILLER_91_129 VGND VGND VPWR VPWR sky130_fd_sc_hd__decap_6
XFILLER_17_259 VPWR VGND VPWR VGND sky130_ef_sc_hd__decap_12
XFILLER_32_218 VGND VGND VPWR VPWR sky130_fd_sc_hd__decap_3
XFILLER_43_51 VGND VGND VPWR VPWR sky130_fd_sc_hd__decap_4
XFILLER_9_447 VGND VGND VPWR VPWR sky130_fd_sc_hd__fill_1
XFILLER_4_141 VGND VGND VPWR VPWR sky130_fd_sc_hd__decap_6
X_3040_ _0695_ _1511_ VGND VGND VPWR VPWR _1514_ sky130_fd_sc_hd__nor2_1
XTAP_TAPCELL_ROW_66_828 VGND VPWR sky130_fd_sc_hd__tapvpwrvgnd_1
XFILLER_51_505 VGND VGND VPWR VPWR sky130_fd_sc_hd__fill_2
XFILLER_51_527 VGND VGND VPWR VPWR sky130_fd_sc_hd__fill_1
XFILLER_63_376 VGND VGND VPWR VPWR sky130_fd_sc_hd__decap_3
X_2824_ net630 net42 _1412_ VGND VGND VPWR VPWR _0478_ sky130_fd_sc_hd__mux2_1
X_2755_ net12 _1387_ _1388_ _1386_ VGND VGND VPWR VPWR _0433_ sky130_fd_sc_hd__a31o_1
X_2686_ _1306_ _1337_ VGND VGND VPWR VPWR _1363_ sky130_fd_sc_hd__xor2_1
X_1706_ net145 _0772_ VGND VGND VPWR VPWR _0773_ sky130_fd_sc_hd__or2_1
X_1637_ _0664_ u_uart_rx.state\[2\] _0697_ VGND VGND VPWR VPWR _0705_ sky130_fd_sc_hd__nand3_1
X_3307_ clknet_leaf_1_clk _0143_ VGND VGND VPWR VPWR u_tx_fifo.mem\[13\]\[2\] sky130_fd_sc_hd__dfxtp_1
XFILLER_48_29 VPWR VGND VPWR VGND sky130_ef_sc_hd__decap_12
XFILLER_86_457 VGND VGND VPWR VPWR sky130_fd_sc_hd__fill_1
XFILLER_58_137 VGND VGND VPWR VPWR sky130_fd_sc_hd__decap_3
X_3238_ clknet_leaf_16_clk _0074_ VGND VGND VPWR VPWR u_rx_fifo.mem\[5\]\[5\] sky130_fd_sc_hd__dfxtp_1
X_3169_ net23 net277 _1586_ VGND VGND VPWR VPWR _0649_ sky130_fd_sc_hd__mux2_1
XFILLER_66_181 VGND VGND VPWR VPWR sky130_fd_sc_hd__fill_2
XFILLER_81_162 VGND VGND VPWR VPWR sky130_fd_sc_hd__decap_6
XTAP_TAPCELL_ROW_37_552 VGND VPWR sky130_fd_sc_hd__tapvpwrvgnd_1
Xfanout22 _0932_ VGND VGND VPWR VPWR net22 sky130_fd_sc_hd__clkbuf_2
Xfanout11 net14 VGND VGND VPWR VPWR net11 sky130_fd_sc_hd__clkbuf_2
XFILLER_80_27 VGND VGND VPWR VPWR sky130_fd_sc_hd__fill_1
Xfanout55 net56 VGND VGND VPWR VPWR net55 sky130_fd_sc_hd__clkbuf_4
Xfanout33 net34 VGND VGND VPWR VPWR net33 sky130_fd_sc_hd__clkbuf_2
Xfanout44 _0718_ VGND VGND VPWR VPWR net44 sky130_fd_sc_hd__clkbuf_4
Xfanout77 rx_fifo_in_data\[4\] VGND VGND VPWR VPWR net77 sky130_fd_sc_hd__dlymetal6s2s_1
Xfanout88 net90 VGND VGND VPWR VPWR net88 sky130_fd_sc_hd__clkbuf_4
Xfanout66 u_tx_fifo.rd_ptr\[0\] VGND VGND VPWR VPWR net66 sky130_fd_sc_hd__buf_4
Xfanout99 net101 VGND VGND VPWR VPWR net99 sky130_fd_sc_hd__clkbuf_4
XFILLER_10_457 VPWR VGND VPWR VGND sky130_ef_sc_hd__decap_12
XFILLER_8_3 VPWR VGND VPWR VGND sky130_ef_sc_hd__decap_12
XFILLER_1_111 VGND VGND VPWR VPWR sky130_fd_sc_hd__fill_1
Xhold480 u_parser.u_decoder.ascii_buf\[0\]\[6\] VGND VGND VPWR VPWR net636 sky130_fd_sc_hd__dlygate4sd3_1
XFILLER_89_251 VGND VGND VPWR VPWR sky130_fd_sc_hd__fill_2
Xhold491 u_uart_rx.low_count\[0\] VGND VGND VPWR VPWR net647 sky130_fd_sc_hd__dlygate4sd3_1
XTAP_TAPCELL_ROW_9_288 VGND VPWR sky130_fd_sc_hd__tapvpwrvgnd_1
XFILLER_49_137 VGND VGND VPWR VPWR sky130_fd_sc_hd__decap_4
XFILLER_92_416 VGND VGND VPWR VPWR sky130_fd_sc_hd__decap_4
XFILLER_38_95 VGND VGND VPWR VPWR sky130_fd_sc_hd__decap_3
XTAP_TAPCELL_ROW_71_875 VGND VPWR sky130_fd_sc_hd__tapvpwrvgnd_1
XFILLER_9_222 VGND VGND VPWR VPWR sky130_fd_sc_hd__fill_2
Xclkload25 clknet_leaf_48_clk VGND VGND VPWR VPWR clkload25/Y sky130_fd_sc_hd__clkinv_4
Xclkload14 clknet_leaf_65_clk VGND VGND VPWR VPWR clkload14/Y sky130_fd_sc_hd__bufinv_16
Xclkload58 clknet_leaf_26_clk VGND VGND VPWR VPWR clkload58/Y sky130_fd_sc_hd__bufinv_16
Xclkload47 clknet_leaf_16_clk VGND VGND VPWR VPWR clkload47/Y sky130_fd_sc_hd__clkinv_4
Xclkload36 clknet_leaf_44_clk VGND VGND VPWR VPWR clkload36/Y sky130_fd_sc_hd__inv_6
X_2540_ u_parser.u_decoder.ascii_buf\[6\]\[2\] _1246_ _1245_ VGND VGND VPWR VPWR _1249_
+ sky130_fd_sc_hd__o21a_1
XFILLER_5_461 VPWR VGND VPWR VGND sky130_ef_sc_hd__decap_12
X_2471_ u_parser.u_decoder.ascii_buf\[9\]\[3\] _1192_ _1193_ u_parser.u_decoder.ascii_buf\[9\]\[7\]
+ u_parser.u_decoder.ascii_buf\[9\]\[6\] VGND VGND VPWR VPWR _1194_ sky130_fd_sc_hd__a2111oi_1
XTAP_TAPCELL_ROW_79_953 VGND VPWR sky130_fd_sc_hd__tapvpwrvgnd_1
X_3023_ net72 net358 _1506_ VGND VGND VPWR VPWR _0583_ sky130_fd_sc_hd__mux2_1
XFILLER_91_471 VPWR VGND VPWR VGND sky130_ef_sc_hd__decap_12
XFILLER_36_365 VGND VGND VPWR VPWR sky130_fd_sc_hd__decap_3
XTAP_TAPCELL_ROW_34_522 VGND VPWR sky130_fd_sc_hd__tapvpwrvgnd_1
Xclkload8 clknet_leaf_58_clk VGND VGND VPWR VPWR clkload8/Y sky130_fd_sc_hd__clkinv_1
X_3787_ clknet_leaf_28_clk _0605_ net139 VGND VGND VPWR VPWR u_uart_rx.sample_div_count\[7\]
+ sky130_fd_sc_hd__dfrtp_1
X_2807_ _1371_ _1407_ net482 VGND VGND VPWR VPWR _0463_ sky130_fd_sc_hd__o21a_1
X_2738_ net43 net609 _1376_ VGND VGND VPWR VPWR _0428_ sky130_fd_sc_hd__mux2_1
X_2669_ _1322_ _1349_ VGND VGND VPWR VPWR _1350_ sky130_fd_sc_hd__xnor2_1
XFILLER_59_39 VPWR VGND VPWR VGND sky130_ef_sc_hd__decap_12
XFILLER_86_210 VGND VGND VPWR VPWR sky130_fd_sc_hd__fill_2
XTAP_TAPCELL_ROW_6_258 VGND VPWR sky130_fd_sc_hd__tapvpwrvgnd_1
XFILLER_75_27 VPWR VGND VPWR VGND sky130_ef_sc_hd__decap_12
Xclkbuf_leaf_66_clk clknet_3_0__leaf_clk VGND VGND VPWR VPWR clknet_leaf_66_clk sky130_fd_sc_hd__clkbuf_8
XFILLER_91_15 VPWR VGND VPWR VGND sky130_ef_sc_hd__decap_12
XFILLER_27_387 VGND VGND VPWR VPWR sky130_fd_sc_hd__decap_4
XFILLER_54_195 VGND VGND VPWR VPWR sky130_fd_sc_hd__fill_1
XFILLER_30_519 VPWR VGND VPWR VGND sky130_ef_sc_hd__decap_12
XFILLER_6_269 VGND VGND VPWR VPWR sky130_fd_sc_hd__fill_1
XFILLER_40_41 VPWR VGND VPWR VGND sky130_ef_sc_hd__decap_12
XFILLER_40_85 VGND VGND VPWR VPWR sky130_fd_sc_hd__decap_3
XFILLER_2_475 VGND VGND VPWR VPWR sky130_fd_sc_hd__fill_1
XTAP_TAPCELL_ROW_76_923 VGND VPWR sky130_fd_sc_hd__tapvpwrvgnd_1
XFILLER_92_246 VGND VGND VPWR VPWR sky130_fd_sc_hd__decap_6
XFILLER_1_57 VGND VGND VPWR VPWR sky130_fd_sc_hd__decap_6
Xclkbuf_leaf_57_clk clknet_3_1__leaf_clk VGND VGND VPWR VPWR clknet_leaf_57_clk sky130_fd_sc_hd__clkbuf_8
XTAP_TAPCELL_ROW_48_658 VGND VPWR sky130_fd_sc_hd__tapvpwrvgnd_1
XFILLER_65_449 VGND VGND VPWR VPWR sky130_fd_sc_hd__fill_2
XFILLER_80_419 VGND VGND VPWR VPWR sky130_fd_sc_hd__fill_1
XFILLER_33_335 VGND VGND VPWR VPWR sky130_fd_sc_hd__fill_1
XFILLER_60_165 VGND VGND VPWR VPWR sky130_fd_sc_hd__decap_4
X_3710_ clknet_leaf_32_clk _0534_ net143 VGND VGND VPWR VPWR u_uart_rx.low_count\[0\]
+ sky130_fd_sc_hd__dfrtp_1
X_1971_ net209 net22 _0947_ VGND VGND VPWR VPWR _0090_ sky130_fd_sc_hd__mux2_1
XFILLER_41_390 VGND VGND VPWR VPWR sky130_fd_sc_hd__fill_2
X_3641_ clknet_leaf_35_clk _0468_ net132 VGND VGND VPWR VPWR u_parser.u_decoder.ascii_buf\[3\]\[4\]
+ sky130_fd_sc_hd__dfrtp_1
XFILLER_60_3 VPWR VGND VPWR VGND sky130_ef_sc_hd__decap_12
X_3572_ clknet_leaf_24_clk _0399_ net119 VGND VGND VPWR VPWR u_parser.u_decoder.ascii_buf\[6\]\[7\]
+ sky130_fd_sc_hd__dfrtp_1
X_2523_ net476 _1235_ net10 VGND VGND VPWR VPWR _0354_ sky130_fd_sc_hd__mux2_1
XTAP_TAPCELL_ROW_93_1089 VGND VPWR sky130_fd_sc_hd__tapvpwrvgnd_1
X_2454_ _0672_ _1178_ _1182_ VGND VGND VPWR VPWR _0338_ sky130_fd_sc_hd__a21oi_1
X_2385_ tag_raw\[38\] net452 net16 VGND VGND VPWR VPWR _0311_ sky130_fd_sc_hd__mux2_1
XTAP_TAPCELL_ROW_3_228 VGND VPWR sky130_fd_sc_hd__tapvpwrvgnd_1
Xinput1 rdm6300_rx_i VGND VGND VPWR VPWR net1 sky130_fd_sc_hd__buf_1
Xclkbuf_leaf_48_clk clknet_3_2__leaf_clk VGND VGND VPWR VPWR clknet_leaf_48_clk sky130_fd_sc_hd__clkbuf_8
XFILLER_83_279 VGND VGND VPWR VPWR sky130_fd_sc_hd__fill_1
X_3006_ net170 net30 _1504_ VGND VGND VPWR VPWR _0568_ sky130_fd_sc_hd__mux2_1
XFILLER_24_302 VGND VGND VPWR VPWR sky130_fd_sc_hd__decap_6
XFILLER_64_471 VGND VGND VPWR VPWR sky130_fd_sc_hd__decap_4
XTAP_TAPCELL_ROW_19_382 VGND VPWR sky130_fd_sc_hd__tapvpwrvgnd_1
XFILLER_24_324 VGND VGND VPWR VPWR sky130_fd_sc_hd__fill_1
XFILLER_51_165 VGND VGND VPWR VPWR sky130_fd_sc_hd__decap_3
XFILLER_86_37 VGND VGND VPWR VPWR sky130_fd_sc_hd__decap_3
XFILLER_86_15 VPWR VGND VPWR VGND sky130_ef_sc_hd__decap_12
XFILLER_87_541 VPWR VGND VPWR VGND sky130_ef_sc_hd__decap_12
XFILLER_74_202 VGND VGND VPWR VPWR sky130_fd_sc_hd__decap_4
Xclkbuf_leaf_39_clk clknet_3_3__leaf_clk VGND VGND VPWR VPWR clknet_leaf_39_clk sky130_fd_sc_hd__clkbuf_8
XFILLER_15_335 VGND VGND VPWR VPWR sky130_fd_sc_hd__fill_1
XFILLER_35_52 VGND VGND VPWR VPWR sky130_fd_sc_hd__decap_4
XFILLER_42_121 VPWR VGND VPWR VGND sky130_ef_sc_hd__decap_12
XTAP_TAPCELL_ROW_45_628 VGND VPWR sky130_fd_sc_hd__tapvpwrvgnd_1
XTAP_TAPCELL_ROW_81_970 VGND VPWR sky130_fd_sc_hd__tapvpwrvgnd_1
XFILLER_15_379 VPWR VGND VPWR VGND sky130_ef_sc_hd__decap_12
XFILLER_11_541 VPWR VGND VPWR VGND sky130_ef_sc_hd__decap_12
XFILLER_51_51 VGND VGND VPWR VPWR sky130_fd_sc_hd__decap_4
XFILLER_76_70 VGND VGND VPWR VPWR sky130_fd_sc_hd__fill_1
X_2170_ tag_raw\[11\] _1031_ VGND VGND VPWR VPWR _1045_ sky130_fd_sc_hd__xor2_1
XFILLER_93_533 VPWR VGND VPWR VGND sky130_ef_sc_hd__decap_12
XFILLER_65_246 VPWR VGND VPWR VGND sky130_ef_sc_hd__decap_12
XFILLER_80_249 VGND VGND VPWR VPWR sky130_fd_sc_hd__decap_3
XTAP_TAPCELL_ROW_16_352 VGND VPWR sky130_fd_sc_hd__tapvpwrvgnd_1
X_1954_ net71 net336 _0944_ VGND VGND VPWR VPWR _0076_ sky130_fd_sc_hd__mux2_1
X_1885_ net25 net360 _0892_ VGND VGND VPWR VPWR _0038_ sky130_fd_sc_hd__mux2_1
X_3624_ clknet_leaf_38_clk _0451_ net130 VGND VGND VPWR VPWR u_parser.u_decoder.ascii_buf\[1\]\[3\]
+ sky130_fd_sc_hd__dfrtp_1
X_3555_ clknet_leaf_56_clk _0382_ net97 VGND VGND VPWR VPWR u_parser.u_decoder.decoded_payload\[38\]
+ sky130_fd_sc_hd__dfrtp_1
XFILLER_0_209 VPWR VGND VPWR VGND sky130_ef_sc_hd__decap_12
X_2506_ net419 _1221_ net7 VGND VGND VPWR VPWR _0351_ sky130_fd_sc_hd__mux2_1
X_3486_ clknet_leaf_43_clk _0313_ net111 VGND VGND VPWR VPWR u_parser.u_decoder.ascii_buf\[5\]\[0\]
+ sky130_fd_sc_hd__dfrtp_1
X_2437_ net612 _1168_ _1170_ VGND VGND VPWR VPWR _0333_ sky130_fd_sc_hd__a21oi_1
XFILLER_84_500 VPWR VGND VPWR VGND sky130_ef_sc_hd__decap_12
X_2368_ tag_raw\[21\] net432 net16 VGND VGND VPWR VPWR _0294_ sky130_fd_sc_hd__mux2_1
XFILLER_29_405 VGND VGND VPWR VPWR sky130_fd_sc_hd__decap_8
XFILLER_56_29 VPWR VGND VPWR VGND sky130_ef_sc_hd__decap_12
XFILLER_84_533 VPWR VGND VPWR VGND sky130_ef_sc_hd__decap_12
X_2299_ _0681_ _1104_ VGND VGND VPWR VPWR _1105_ sky130_fd_sc_hd__or2_1
XFILLER_64_290 VPWR VGND VPWR VGND sky130_ef_sc_hd__decap_12
XFILLER_12_305 VGND VGND VPWR VPWR sky130_fd_sc_hd__decap_3
XFILLER_24_176 VGND VGND VPWR VPWR sky130_fd_sc_hd__decap_4
XTAP_TAPCELL_ROW_50_675 VGND VPWR sky130_fd_sc_hd__tapvpwrvgnd_1
XFILLER_87_371 VGND VGND VPWR VPWR sky130_fd_sc_hd__decap_3
XFILLER_87_393 VPWR VGND VPWR VGND sky130_ef_sc_hd__decap_12
XFILLER_47_279 VGND VGND VPWR VPWR sky130_fd_sc_hd__fill_1
XTAP_TAPCELL_ROW_58_753 VGND VPWR sky130_fd_sc_hd__tapvpwrvgnd_1
XFILLER_90_525 VGND VGND VPWR VPWR sky130_fd_sc_hd__decap_6
XFILLER_62_238 VGND VGND VPWR VPWR sky130_fd_sc_hd__decap_4
XTAP_TAPCELL_ROW_13_322 VGND VPWR sky130_fd_sc_hd__tapvpwrvgnd_1
XFILLER_30_157 VGND VGND VPWR VPWR sky130_fd_sc_hd__fill_1
XFILLER_7_342 VGND VGND VPWR VPWR sky130_fd_sc_hd__fill_2
XFILLER_7_375 VPWR VGND VPWR VGND sky130_ef_sc_hd__decap_12
X_1670_ net145 _0736_ VGND VGND VPWR VPWR _0737_ sky130_fd_sc_hd__or2_1
Xhold309 u_parser.u_decoder.decoded_payload\[35\] VGND VGND VPWR VPWR net465 sky130_fd_sc_hd__dlygate4sd3_1
X_3340_ clknet_leaf_58_clk _0173_ VGND VGND VPWR VPWR u_tx_fifo.mem\[3\]\[0\] sky130_fd_sc_hd__dfxtp_1
XTAP_TAPCELL_ROW_90_1059 VGND VPWR sky130_fd_sc_hd__tapvpwrvgnd_1
X_3271_ clknet_leaf_10_clk _0107_ VGND VGND VPWR VPWR u_rx_fifo.mem\[11\]\[6\] sky130_fd_sc_hd__dfxtp_1
XFILLER_23_3 VGND VGND VPWR VPWR sky130_fd_sc_hd__fill_1
X_2222_ net480 net530 net54 VGND VGND VPWR VPWR _0226_ sky130_fd_sc_hd__mux2_1
X_2153_ tag_raw\[17\] _1006_ VGND VGND VPWR VPWR _1030_ sky130_fd_sc_hd__xnor2_1
XFILLER_66_533 VPWR VGND VPWR VGND sky130_ef_sc_hd__decap_12
XFILLER_53_205 VGND VGND VPWR VPWR sky130_fd_sc_hd__fill_1
X_2084_ net36 u_parser.u_decoder.ascii_buf\[11\]\[2\] _0967_ VGND VGND VPWR VPWR _0183_
+ sky130_fd_sc_hd__mux2_1
X_2986_ _0668_ net445 VGND VGND VPWR VPWR _0554_ sky130_fd_sc_hd__and2_1
X_1937_ _0884_ _0942_ VGND VGND VPWR VPWR _0943_ sky130_fd_sc_hd__nor2_4
X_1868_ u_parser.u_packet_encoder.byte_index\[0\] u_parser.u_packet_encoder.byte_index\[1\]
+ VGND VGND VPWR VPWR _0898_ sky130_fd_sc_hd__nand2b_1
X_3607_ clknet_leaf_37_clk _0434_ net129 VGND VGND VPWR VPWR u_parser.u_decoder.decoded_checksum_rx\[2\]
+ sky130_fd_sc_hd__dfrtp_1
X_1799_ u_rx_fifo.level\[1\] _0850_ VGND VGND VPWR VPWR _0854_ sky130_fd_sc_hd__nand2_1
X_3538_ clknet_leaf_57_clk _0365_ net97 VGND VGND VPWR VPWR u_parser.u_decoder.decoded_payload\[21\]
+ sky130_fd_sc_hd__dfrtp_1
XFILLER_1_529 VPWR VGND VPWR VGND sky130_ef_sc_hd__decap_12
X_3469_ clknet_leaf_39_clk _0296_ net100 VGND VGND VPWR VPWR tag_raw\[23\] sky130_fd_sc_hd__dfrtp_1
XFILLER_67_39 VGND VGND VPWR VPWR sky130_fd_sc_hd__fill_1
XFILLER_57_522 VGND VGND VPWR VPWR sky130_fd_sc_hd__fill_2
XFILLER_69_393 VPWR VGND VPWR VGND sky130_ef_sc_hd__decap_12
XFILLER_29_268 VPWR VGND VPWR VGND sky130_ef_sc_hd__decap_12
XFILLER_83_27 VPWR VGND VPWR VGND sky130_ef_sc_hd__decap_12
XTAP_TAPCELL_ROW_55_723 VGND VPWR sky130_fd_sc_hd__tapvpwrvgnd_1
XTAP_TAPCELL_ROW_27_458 VGND VPWR sky130_fd_sc_hd__tapvpwrvgnd_1
XFILLER_4_356 VGND VGND VPWR VPWR sky130_fd_sc_hd__decap_8
XFILLER_79_113 VGND VGND VPWR VPWR sky130_fd_sc_hd__decap_4
XFILLER_4_389 VPWR VGND VPWR VGND sky130_ef_sc_hd__decap_12
X_2840_ _1421_ u_tx_fifo.level\[2\] _1413_ VGND VGND VPWR VPWR _1424_ sky130_fd_sc_hd__or3b_1
XFILLER_31_444 VGND VGND VPWR VPWR sky130_fd_sc_hd__decap_4
X_2771_ net155 _0846_ u_parser.u_decoder.decoded_checksum_rx\[5\] VGND VGND VPWR VPWR
+ _1401_ sky130_fd_sc_hd__o21a_1
XFILLER_11_190 VGND VGND VPWR VPWR sky130_fd_sc_hd__decap_4
X_1722_ u_parser.u_decoder.timeout_count\[12\] u_parser.u_decoder.timeout_count\[11\]
+ u_parser.u_decoder.timeout_count\[10\] _0788_ u_parser.u_decoder.timeout_count\[13\]
+ VGND VGND VPWR VPWR _0789_ sky130_fd_sc_hd__o41a_1
X_1653_ u_rx_fifo.mem\[8\]\[4\] u_rx_fifo.mem\[9\]\[4\] u_rx_fifo.mem\[10\]\[4\] u_rx_fifo.mem\[11\]\[4\]
+ net151 net147 VGND VGND VPWR VPWR _0720_ sky130_fd_sc_hd__mux4_1
Xhold117 u_rx_fifo.mem\[12\]\[3\] VGND VGND VPWR VPWR net273 sky130_fd_sc_hd__dlygate4sd3_1
Xhold106 u_rx_fifo.mem\[10\]\[7\] VGND VGND VPWR VPWR net262 sky130_fd_sc_hd__dlygate4sd3_1
XPHY_EDGE_ROW_9_Right_9 VGND VGND VPWR VPWR sky130_fd_sc_hd__decap_3
Xhold128 u_tx_fifo.mem\[3\]\[5\] VGND VGND VPWR VPWR net284 sky130_fd_sc_hd__dlygate4sd3_1
Xhold139 u_rx_fifo.mem\[15\]\[3\] VGND VGND VPWR VPWR net295 sky130_fd_sc_hd__dlygate4sd3_1
X_3323_ clknet_leaf_10_clk _0159_ VGND VGND VPWR VPWR u_rx_fifo.mem\[12\]\[2\] sky130_fd_sc_hd__dfxtp_1
X_3254_ clknet_leaf_2_clk _0090_ VGND VGND VPWR VPWR u_tx_fifo.mem\[6\]\[5\] sky130_fd_sc_hd__dfxtp_1
XFILLER_39_500 VGND VGND VPWR VPWR sky130_fd_sc_hd__decap_4
XFILLER_85_138 VGND VGND VPWR VPWR sky130_fd_sc_hd__decap_4
X_2205_ tag_raw\[12\] net477 net54 VGND VGND VPWR VPWR _0209_ sky130_fd_sc_hd__mux2_1
XTAP_TAPCELL_ROW_69_859 VGND VPWR sky130_fd_sc_hd__tapvpwrvgnd_1
X_3185_ clknet_leaf_14_clk _0021_ VGND VGND VPWR VPWR u_rx_fifo.mem\[6\]\[0\] sky130_fd_sc_hd__dfxtp_1
X_2136_ _1004_ _1013_ VGND VGND VPWR VPWR _1014_ sky130_fd_sc_hd__xnor2_2
XFILLER_81_344 VGND VGND VPWR VPWR sky130_fd_sc_hd__decap_8
XFILLER_81_333 VGND VGND VPWR VPWR sky130_fd_sc_hd__decap_3
X_2067_ u_tx_fifo.wr_ptr\[2\] u_tx_fifo.wr_ptr\[3\] VGND VGND VPWR VPWR _0961_ sky130_fd_sc_hd__or2_2
XFILLER_22_433 VGND VGND VPWR VPWR sky130_fd_sc_hd__decap_3
XTAP_TAPCELL_ROW_24_428 VGND VPWR sky130_fd_sc_hd__tapvpwrvgnd_1
XTAP_TAPCELL_ROW_60_770 VGND VPWR sky130_fd_sc_hd__tapvpwrvgnd_1
X_2969_ net580 _1487_ _1489_ VGND VGND VPWR VPWR _0546_ sky130_fd_sc_hd__o21a_1
XFILLER_78_27 VGND VGND VPWR VPWR sky130_fd_sc_hd__fill_1
XFILLER_1_337 VGND VGND VPWR VPWR sky130_fd_sc_hd__decap_3
XFILLER_45_503 VGND VGND VPWR VPWR sky130_fd_sc_hd__fill_1
XFILLER_57_341 VGND VGND VPWR VPWR sky130_fd_sc_hd__decap_4
XFILLER_4_35 VGND VGND VPWR VPWR sky130_fd_sc_hd__fill_1
XFILLER_48_330 VGND VGND VPWR VPWR sky130_fd_sc_hd__fill_1
XTAP_TAPCELL_ROW_89_1050 VGND VPWR sky130_fd_sc_hd__tapvpwrvgnd_1
XTAP_TAPCELL_ROW_66_829 VGND VPWR sky130_fd_sc_hd__tapvpwrvgnd_1
XFILLER_90_141 VGND VGND VPWR VPWR sky130_fd_sc_hd__decap_6
XFILLER_90_3 VPWR VGND VPWR VGND sky130_ef_sc_hd__decap_12
X_2823_ net590 net35 _1412_ VGND VGND VPWR VPWR _0477_ sky130_fd_sc_hd__mux2_1
X_2754_ u_parser.u_decoder.ascii_buf\[11\]\[1\] _1384_ VGND VGND VPWR VPWR _1388_
+ sky130_fd_sc_hd__xor2_1
X_1705_ u_rx_fifo.mem\[8\]\[5\] u_rx_fifo.mem\[9\]\[5\] u_rx_fifo.mem\[10\]\[5\] u_rx_fifo.mem\[11\]\[5\]
+ net151 net147 VGND VGND VPWR VPWR _0772_ sky130_fd_sc_hd__mux4_1
X_2685_ net571 _1362_ net8 VGND VGND VPWR VPWR _0389_ sky130_fd_sc_hd__mux2_1
X_1636_ _0700_ _0703_ VGND VGND VPWR VPWR _0704_ sky130_fd_sc_hd__and2b_1
X_3306_ clknet_leaf_0_clk _0142_ VGND VGND VPWR VPWR u_tx_fifo.mem\[13\]\[1\] sky130_fd_sc_hd__dfxtp_1
X_3237_ clknet_leaf_16_clk _0073_ VGND VGND VPWR VPWR u_rx_fifo.mem\[5\]\[4\] sky130_fd_sc_hd__dfxtp_1
X_3168_ net25 net275 _1586_ VGND VGND VPWR VPWR _0648_ sky130_fd_sc_hd__mux2_1
XFILLER_27_525 VPWR VGND VPWR VGND sky130_ef_sc_hd__decap_12
X_2119_ tag_raw\[7\] _0996_ VGND VGND VPWR VPWR _0997_ sky130_fd_sc_hd__xnor2_1
XFILLER_64_29 VPWR VGND VPWR VGND sky130_ef_sc_hd__decap_12
X_3099_ u_uart_rx.sample_div_count\[13\] _0666_ net655 _1549_ _1552_ VGND VGND VPWR
+ VPWR _0613_ sky130_fd_sc_hd__a41o_1
XFILLER_81_152 VGND VGND VPWR VPWR sky130_fd_sc_hd__fill_1
XTAP_TAPCELL_ROW_37_553 VGND VPWR sky130_fd_sc_hd__tapvpwrvgnd_1
Xfanout12 net13 VGND VGND VPWR VPWR net12 sky130_fd_sc_hd__buf_4
Xfanout56 net57 VGND VGND VPWR VPWR net56 sky130_fd_sc_hd__clkbuf_4
Xfanout23 _0919_ VGND VGND VPWR VPWR net23 sky130_fd_sc_hd__buf_2
Xfanout34 _0923_ VGND VGND VPWR VPWR net34 sky130_fd_sc_hd__clkbuf_2
Xfanout78 net79 VGND VGND VPWR VPWR net78 sky130_fd_sc_hd__clkbuf_2
Xfanout89 net90 VGND VGND VPWR VPWR net89 sky130_fd_sc_hd__buf_2
Xfanout67 u_tx_fifo.rd_ptr\[0\] VGND VGND VPWR VPWR net67 sky130_fd_sc_hd__buf_2
XFILLER_22_274 VGND VGND VPWR VPWR sky130_fd_sc_hd__decap_6
XFILLER_10_469 VGND VGND VPWR VPWR sky130_fd_sc_hd__decap_6
XFILLER_89_15 VPWR VGND VPWR VGND sky130_ef_sc_hd__decap_12
XFILLER_89_230 VGND VGND VPWR VPWR sky130_fd_sc_hd__fill_1
Xhold481 u_parser.u_decoder.timeout_count\[5\] VGND VGND VPWR VPWR net637 sky130_fd_sc_hd__dlygate4sd3_1
Xhold470 u_parser.u_decoder.ascii_buf\[0\]\[2\] VGND VGND VPWR VPWR net626 sky130_fd_sc_hd__dlygate4sd3_1
XTAP_TAPCELL_ROW_9_289 VGND VPWR sky130_fd_sc_hd__tapvpwrvgnd_1
XFILLER_1_167 VGND VGND VPWR VPWR sky130_fd_sc_hd__fill_1
XFILLER_49_105 VGND VGND VPWR VPWR sky130_fd_sc_hd__decap_6
Xhold492 u_uart_rx.low_count\[7\] VGND VGND VPWR VPWR net648 sky130_fd_sc_hd__dlygate4sd3_1
XFILLER_38_41 VGND VGND VPWR VPWR sky130_fd_sc_hd__decap_8
XFILLER_38_85 VGND VGND VPWR VPWR sky130_fd_sc_hd__fill_1
XFILLER_60_303 VGND VGND VPWR VPWR sky130_fd_sc_hd__decap_4
XFILLER_72_141 VGND VGND VPWR VPWR sky130_fd_sc_hd__fill_2
XFILLER_60_369 VGND VGND VPWR VPWR sky130_fd_sc_hd__fill_1
XTAP_TAPCELL_ROW_71_876 VGND VPWR sky130_fd_sc_hd__tapvpwrvgnd_1
XFILLER_9_201 VGND VGND VPWR VPWR sky130_fd_sc_hd__fill_1
XFILLER_9_289 VGND VGND VPWR VPWR sky130_fd_sc_hd__fill_1
Xclkload26 clknet_leaf_49_clk VGND VGND VPWR VPWR clkload26/Y sky130_fd_sc_hd__clkinv_4
Xclkload15 clknet_leaf_66_clk VGND VGND VPWR VPWR clkload15/Y sky130_fd_sc_hd__clkinv_8
Xclkload59 clknet_leaf_27_clk VGND VGND VPWR VPWR clkload59/Y sky130_fd_sc_hd__clkinvlp_4
Xclkload48 clknet_leaf_18_clk VGND VGND VPWR VPWR clkload48/Y sky130_fd_sc_hd__bufinv_16
Xclkload37 clknet_leaf_55_clk VGND VGND VPWR VPWR clkload37/Y sky130_fd_sc_hd__clkinvlp_4
XFILLER_5_473 VPWR VGND VPWR VGND sky130_ef_sc_hd__decap_12
X_2470_ u_parser.u_decoder.ascii_buf\[9\]\[4\] u_parser.u_decoder.ascii_buf\[9\]\[5\]
+ VGND VGND VPWR VPWR _1193_ sky130_fd_sc_hd__nand2_1
XTAP_TAPCELL_ROW_79_954 VGND VPWR sky130_fd_sc_hd__tapvpwrvgnd_1
XFILLER_83_417 VGND VGND VPWR VPWR sky130_fd_sc_hd__decap_8
X_3022_ net74 net354 _1506_ VGND VGND VPWR VPWR _0582_ sky130_fd_sc_hd__mux2_1
XFILLER_91_483 VPWR VGND VPWR VGND sky130_ef_sc_hd__decap_12
XTAP_TAPCELL_ROW_34_523 VGND VPWR sky130_fd_sc_hd__tapvpwrvgnd_1
XFILLER_51_358 VGND VGND VPWR VPWR sky130_fd_sc_hd__decap_3
Xclkload9 clknet_leaf_59_clk VGND VGND VPWR VPWR clkload9/X sky130_fd_sc_hd__clkbuf_4
X_3786_ clknet_leaf_27_clk _0604_ net139 VGND VGND VPWR VPWR u_uart_rx.sample_div_count\[6\]
+ sky130_fd_sc_hd__dfrtp_1
X_2806_ net557 net42 _1410_ VGND VGND VPWR VPWR _0462_ sky130_fd_sc_hd__mux2_1
X_2737_ net44 u_parser.u_decoder.ascii_buf\[8\]\[3\] _1376_ VGND VGND VPWR VPWR _0427_
+ sky130_fd_sc_hd__mux2_1
X_2668_ _1347_ _1348_ VGND VGND VPWR VPWR _1349_ sky130_fd_sc_hd__xnor2_1
X_1619_ u_uart_rx.sample_phase\[4\] _0688_ VGND VGND VPWR VPWR _0689_ sky130_fd_sc_hd__or2_1
X_2599_ u_parser.u_decoder.ascii_buf\[2\]\[1\] u_parser.u_decoder.ascii_buf\[2\]\[2\]
+ u_parser.u_decoder.ascii_buf\[2\]\[3\] VGND VGND VPWR VPWR _1294_ sky130_fd_sc_hd__o21ai_1
XTAP_TAPCELL_ROW_6_259 VGND VPWR sky130_fd_sc_hd__tapvpwrvgnd_1
XFILLER_86_266 VGND VGND VPWR VPWR sky130_fd_sc_hd__decap_8
XFILLER_59_458 VGND VGND VPWR VPWR sky130_fd_sc_hd__decap_3
XFILLER_59_469 VPWR VGND VPWR VGND sky130_ef_sc_hd__decap_12
XFILLER_75_39 VPWR VGND VPWR VGND sky130_ef_sc_hd__decap_12
XFILLER_27_333 VGND VGND VPWR VPWR sky130_fd_sc_hd__decap_3
XFILLER_91_27 VPWR VGND VPWR VGND sky130_ef_sc_hd__decap_12
XFILLER_24_98 VGND VGND VPWR VPWR sky130_fd_sc_hd__decap_8
XFILLER_40_53 VGND VGND VPWR VPWR sky130_fd_sc_hd__decap_8
XFILLER_2_421 VPWR VGND VPWR VGND sky130_ef_sc_hd__decap_12
XFILLER_77_200 VGND VGND VPWR VPWR sky130_fd_sc_hd__decap_4
XFILLER_49_51 VGND VGND VPWR VPWR sky130_fd_sc_hd__decap_4
XTAP_TAPCELL_ROW_76_924 VGND VPWR sky130_fd_sc_hd__tapvpwrvgnd_1
XTAP_TAPCELL_ROW_86_1020 VGND VPWR sky130_fd_sc_hd__tapvpwrvgnd_1
XFILLER_18_322 VPWR VGND VPWR VGND sky130_ef_sc_hd__decap_12
XTAP_TAPCELL_ROW_48_659 VGND VPWR sky130_fd_sc_hd__tapvpwrvgnd_1
XFILLER_92_269 VPWR VGND VPWR VGND sky130_ef_sc_hd__decap_12
X_1970_ net245 net31 _0947_ VGND VGND VPWR VPWR _0089_ sky130_fd_sc_hd__mux2_1
X_3640_ clknet_leaf_35_clk _0467_ net132 VGND VGND VPWR VPWR u_parser.u_decoder.ascii_buf\[3\]\[3\]
+ sky130_fd_sc_hd__dfrtp_1
X_3571_ clknet_leaf_23_clk _0398_ net117 VGND VGND VPWR VPWR u_parser.u_decoder.ascii_buf\[6\]\[6\]
+ sky130_fd_sc_hd__dfrtp_1
XFILLER_53_3 VPWR VGND VPWR VGND sky130_ef_sc_hd__decap_12
X_2522_ _1231_ _1234_ VGND VGND VPWR VPWR _1235_ sky130_fd_sc_hd__and2_1
XFILLER_5_281 VGND VGND VPWR VPWR sky130_fd_sc_hd__decap_4
X_2453_ _1165_ _1181_ net4 VGND VGND VPWR VPWR _1182_ sky130_fd_sc_hd__a21bo_1
X_2384_ tag_raw\[37\] net444 net15 VGND VGND VPWR VPWR _0310_ sky130_fd_sc_hd__mux2_1
XTAP_TAPCELL_ROW_3_229 VGND VPWR sky130_fd_sc_hd__tapvpwrvgnd_1
XFILLER_68_288 VPWR VGND VPWR VGND sky130_ef_sc_hd__decap_12
XFILLER_83_225 VGND VGND VPWR VPWR sky130_fd_sc_hd__decap_4
X_3005_ net182 net20 _1504_ VGND VGND VPWR VPWR _0567_ sky130_fd_sc_hd__mux2_1
XFILLER_36_141 VGND VGND VPWR VPWR sky130_fd_sc_hd__decap_4
XTAP_TAPCELL_ROW_19_383 VGND VPWR sky130_fd_sc_hd__tapvpwrvgnd_1
XFILLER_51_111 VGND VGND VPWR VPWR sky130_fd_sc_hd__fill_1
XFILLER_20_531 VGND VGND VPWR VPWR sky130_fd_sc_hd__fill_1
X_3838_ clknet_leaf_63_clk _0654_ VGND VGND VPWR VPWR u_tx_fifo.mem\[11\]\[7\] sky130_fd_sc_hd__dfxtp_1
XFILLER_20_553 VGND VGND VPWR VPWR sky130_fd_sc_hd__fill_2
X_3769_ clknet_leaf_13_clk _0587_ VGND VGND VPWR VPWR u_rx_fifo.mem\[2\]\[2\] sky130_fd_sc_hd__dfxtp_1
XFILLER_86_27 VGND VGND VPWR VPWR sky130_fd_sc_hd__fill_1
XFILLER_87_553 VGND VGND VPWR VPWR sky130_fd_sc_hd__fill_2
XFILLER_59_233 VGND VGND VPWR VPWR sky130_fd_sc_hd__decap_4
XFILLER_47_428 VPWR VGND VPWR VGND sky130_ef_sc_hd__decap_12
XTAP_TAPCELL_ROW_45_629 VGND VPWR sky130_fd_sc_hd__tapvpwrvgnd_1
XFILLER_42_133 VGND VGND VPWR VPWR sky130_fd_sc_hd__decap_6
XFILLER_70_453 VGND VGND VPWR VPWR sky130_fd_sc_hd__decap_3
XTAP_TAPCELL_ROW_81_971 VGND VPWR sky130_fd_sc_hd__tapvpwrvgnd_1
XFILLER_42_177 VGND VGND VPWR VPWR sky130_fd_sc_hd__fill_1
XFILLER_70_464 VPWR VGND VPWR VGND sky130_ef_sc_hd__decap_12
XFILLER_11_553 VGND VGND VPWR VPWR sky130_fd_sc_hd__fill_2
XPHY_EDGE_ROW_2_Left_96 VGND VGND VPWR VPWR sky130_fd_sc_hd__decap_3
XFILLER_78_553 VGND VGND VPWR VPWR sky130_fd_sc_hd__fill_2
XFILLER_93_501 VGND VGND VPWR VPWR sky130_fd_sc_hd__decap_3
XFILLER_93_545 VGND VGND VPWR VPWR sky130_fd_sc_hd__decap_8
XFILLER_65_225 VGND VGND VPWR VPWR sky130_fd_sc_hd__decap_4
XFILLER_65_258 VGND VGND VPWR VPWR sky130_fd_sc_hd__decap_3
XFILLER_33_100 VGND VGND VPWR VPWR sky130_fd_sc_hd__decap_3
XFILLER_33_133 VGND VGND VPWR VPWR sky130_fd_sc_hd__fill_1
XTAP_TAPCELL_ROW_16_353 VGND VPWR sky130_fd_sc_hd__tapvpwrvgnd_1
X_1953_ net72 net384 _0944_ VGND VGND VPWR VPWR _0075_ sky130_fd_sc_hd__mux2_1
XFILLER_33_199 VGND VGND VPWR VPWR sky130_fd_sc_hd__fill_1
X_1884_ u_parser.u_packet_encoder.crc_latched\[1\] _0904_ _0910_ _0912_ VGND VGND
+ VPWR VPWR _0913_ sky130_fd_sc_hd__o22a_2
X_3623_ clknet_leaf_41_clk _0450_ net107 VGND VGND VPWR VPWR u_parser.u_decoder.ascii_buf\[1\]\[2\]
+ sky130_fd_sc_hd__dfrtp_1
X_3554_ clknet_leaf_56_clk _0381_ net99 VGND VGND VPWR VPWR u_parser.u_decoder.decoded_payload\[37\]
+ sky130_fd_sc_hd__dfrtp_1
X_3485_ clknet_leaf_55_clk _0312_ net99 VGND VGND VPWR VPWR tag_raw\[39\] sky130_fd_sc_hd__dfrtp_4
X_2505_ u_parser.u_decoder.ascii_buf\[8\]\[3\] _1209_ _1214_ VGND VGND VPWR VPWR _1221_
+ sky130_fd_sc_hd__a21o_1
X_2436_ u_parser.u_decoder.timeout_count\[8\] _1168_ net4 VGND VGND VPWR VPWR _1170_
+ sky130_fd_sc_hd__o21ai_1
XFILLER_84_512 VPWR VGND VPWR VGND sky130_ef_sc_hd__decap_12
XPHY_EDGE_ROW_16_Left_110 VGND VGND VPWR VPWR sky130_fd_sc_hd__decap_3
X_2367_ tag_raw\[20\] net483 net16 VGND VGND VPWR VPWR _0293_ sky130_fd_sc_hd__mux2_1
XFILLER_84_545 VGND VGND VPWR VPWR sky130_fd_sc_hd__decap_8
X_2298_ u_tx_fifo.mem\[12\]\[4\] u_tx_fifo.mem\[13\]\[4\] u_tx_fifo.mem\[14\]\[4\]
+ u_tx_fifo.mem\[15\]\[4\] net66 net62 VGND VGND VPWR VPWR _1104_ sky130_fd_sc_hd__mux4_1
XFILLER_71_206 VGND VGND VPWR VPWR sky130_fd_sc_hd__fill_2
XFILLER_72_29 VPWR VGND VPWR VGND sky130_ef_sc_hd__decap_12
XTAP_TAPCELL_ROW_50_676 VGND VPWR sky130_fd_sc_hd__tapvpwrvgnd_1
XFILLER_21_88 VGND VGND VPWR VPWR sky130_fd_sc_hd__fill_1
XFILLER_79_317 VPWR VGND VPWR VGND sky130_ef_sc_hd__decap_12
XFILLER_87_350 VGND VGND VPWR VPWR sky130_fd_sc_hd__fill_1
XFILLER_46_41 VPWR VGND VPWR VGND sky130_ef_sc_hd__decap_12
XTAP_TAPCELL_ROW_58_754 VGND VPWR sky130_fd_sc_hd__tapvpwrvgnd_1
XFILLER_28_494 VGND VGND VPWR VPWR sky130_fd_sc_hd__fill_1
XFILLER_46_85 VPWR VGND VPWR VGND sky130_ef_sc_hd__decap_12
XFILLER_70_261 VPWR VGND VPWR VGND sky130_ef_sc_hd__decap_12
XTAP_TAPCELL_ROW_13_323 VGND VPWR sky130_fd_sc_hd__tapvpwrvgnd_1
XFILLER_7_387 VGND VGND VPWR VPWR sky130_fd_sc_hd__decap_4
X_3270_ clknet_leaf_11_clk _0106_ VGND VGND VPWR VPWR u_rx_fifo.mem\[11\]\[5\] sky130_fd_sc_hd__dfxtp_1
X_2221_ net506 net529 net53 VGND VGND VPWR VPWR _0225_ sky130_fd_sc_hd__mux2_1
XFILLER_16_3 VGND VGND VPWR VPWR sky130_fd_sc_hd__decap_8
X_2152_ _1029_ net540 net51 VGND VGND VPWR VPWR _0189_ sky130_fd_sc_hd__mux2_1
XFILLER_66_545 VGND VGND VPWR VPWR sky130_fd_sc_hd__decap_8
XFILLER_38_269 VPWR VGND VPWR VGND sky130_ef_sc_hd__decap_12
X_2083_ net38 u_parser.u_decoder.ascii_buf\[11\]\[1\] _0967_ VGND VGND VPWR VPWR _0182_
+ sky130_fd_sc_hd__mux2_1
XFILLER_53_239 VGND VGND VPWR VPWR sky130_fd_sc_hd__decap_4
XFILLER_46_280 VGND VGND VPWR VPWR sky130_fd_sc_hd__fill_1
XFILLER_34_475 VGND VGND VPWR VPWR sky130_fd_sc_hd__fill_1
X_2985_ _0668_ net485 VGND VGND VPWR VPWR _0553_ sky130_fd_sc_hd__and2_1
X_1936_ u_rx_fifo.wr_ptr\[2\] u_rx_fifo.wr_ptr\[3\] VGND VGND VPWR VPWR _0942_ sky130_fd_sc_hd__nand2b_2
X_1867_ u_parser.u_packet_encoder.tag_latched\[8\] _0894_ _0896_ u_parser.u_packet_encoder.tag_latched\[32\]
+ VGND VGND VPWR VPWR _0897_ sky130_fd_sc_hd__a22o_1
X_1798_ u_rx_fifo.level\[1\] _0850_ VGND VGND VPWR VPWR _0853_ sky130_fd_sc_hd__or2_1
X_3606_ clknet_leaf_36_clk _0433_ net129 VGND VGND VPWR VPWR u_parser.u_decoder.decoded_checksum_rx\[1\]
+ sky130_fd_sc_hd__dfrtp_1
X_3537_ clknet_leaf_57_clk _0364_ net95 VGND VGND VPWR VPWR u_parser.u_decoder.decoded_payload\[20\]
+ sky130_fd_sc_hd__dfrtp_1
X_3468_ clknet_leaf_57_clk _0295_ net95 VGND VGND VPWR VPWR tag_raw\[22\] sky130_fd_sc_hd__dfrtp_1
X_2419_ _0786_ _1152_ VGND VGND VPWR VPWR _1159_ sky130_fd_sc_hd__and2_1
XFILLER_76_309 VGND VGND VPWR VPWR sky130_fd_sc_hd__decap_6
X_3399_ clknet_leaf_41_clk _0232_ net106 VGND VGND VPWR VPWR u_parser.u_packet_encoder.tag_latched\[35\]
+ sky130_fd_sc_hd__dfrtp_1
XFILLER_69_361 VGND VGND VPWR VPWR sky130_fd_sc_hd__decap_8
XFILLER_29_225 VGND VGND VPWR VPWR sky130_fd_sc_hd__decap_6
XFILLER_29_247 VPWR VGND VPWR VGND sky130_ef_sc_hd__decap_12
XFILLER_83_39 VPWR VGND VPWR VGND sky130_ef_sc_hd__decap_12
XFILLER_16_11 VGND VGND VPWR VPWR sky130_fd_sc_hd__fill_1
XTAP_TAPCELL_ROW_55_724 VGND VPWR sky130_fd_sc_hd__tapvpwrvgnd_1
XTAP_TAPCELL_ROW_27_459 VGND VPWR sky130_fd_sc_hd__tapvpwrvgnd_1
XFILLER_52_261 VGND VGND VPWR VPWR sky130_fd_sc_hd__decap_3
XFILLER_40_434 VGND VGND VPWR VPWR sky130_fd_sc_hd__fill_2
XFILLER_20_191 VGND VGND VPWR VPWR sky130_fd_sc_hd__fill_1
XFILLER_4_313 VPWR VGND VPWR VGND sky130_ef_sc_hd__decap_12
XFILLER_79_169 VGND VGND VPWR VPWR sky130_fd_sc_hd__fill_2
XFILLER_67_309 VGND VGND VPWR VPWR sky130_fd_sc_hd__decap_3
XFILLER_57_51 VGND VGND VPWR VPWR sky130_fd_sc_hd__decap_4
XFILLER_16_486 VGND VGND VPWR VPWR sky130_fd_sc_hd__decap_6
XFILLER_43_272 VGND VGND VPWR VPWR sky130_fd_sc_hd__fill_2
X_2770_ u_parser.u_decoder.decoded_checksum_rx\[4\] _1400_ net12 VGND VGND VPWR VPWR
+ _0436_ sky130_fd_sc_hd__mux2_1
X_1721_ u_parser.u_decoder.timeout_count\[7\] u_parser.u_decoder.timeout_count\[6\]
+ _0787_ u_parser.u_decoder.timeout_count\[8\] VGND VGND VPWR VPWR _0788_ sky130_fd_sc_hd__o31a_1
Xhold107 u_tx_fifo.mem\[13\]\[1\] VGND VGND VPWR VPWR net263 sky130_fd_sc_hd__dlygate4sd3_1
X_1652_ u_rx_fifo.mem\[12\]\[4\] u_rx_fifo.mem\[13\]\[4\] u_rx_fifo.mem\[14\]\[4\]
+ u_rx_fifo.mem\[15\]\[4\] net151 net147 VGND VGND VPWR VPWR _0719_ sky130_fd_sc_hd__mux4_1
Xhold129 u_rx_fifo.mem\[10\]\[5\] VGND VGND VPWR VPWR net285 sky130_fd_sc_hd__dlygate4sd3_1
Xhold118 u_rx_fifo.mem\[9\]\[7\] VGND VGND VPWR VPWR net274 sky130_fd_sc_hd__dlygate4sd3_1
X_3322_ clknet_leaf_21_clk _0158_ VGND VGND VPWR VPWR u_rx_fifo.mem\[12\]\[1\] sky130_fd_sc_hd__dfxtp_1
X_3253_ clknet_leaf_1_clk _0089_ VGND VGND VPWR VPWR u_tx_fifo.mem\[6\]\[4\] sky130_fd_sc_hd__dfxtp_1
X_3184_ clknet_leaf_59_clk _0020_ net93 VGND VGND VPWR VPWR parser_tx_valid sky130_fd_sc_hd__dfrtp_1
X_2204_ tag_raw\[11\] net463 net56 VGND VGND VPWR VPWR _0208_ sky130_fd_sc_hd__mux2_1
X_2135_ tag_raw\[24\] _0982_ VGND VGND VPWR VPWR _1013_ sky130_fd_sc_hd__xnor2_1
XFILLER_66_386 VGND VGND VPWR VPWR sky130_fd_sc_hd__fill_2
X_2066_ net188 net29 _0960_ VGND VGND VPWR VPWR _0172_ sky130_fd_sc_hd__mux2_1
XTAP_TAPCELL_ROW_24_429 VGND VPWR sky130_fd_sc_hd__tapvpwrvgnd_1
X_2968_ u_uart_rx.low_count\[12\] _1487_ net87 VGND VGND VPWR VPWR _1489_ sky130_fd_sc_hd__a21oi_1
XTAP_TAPCELL_ROW_60_771 VGND VPWR sky130_fd_sc_hd__tapvpwrvgnd_1
X_1919_ _0868_ _0875_ VGND VGND VPWR VPWR _0941_ sky130_fd_sc_hd__nor2_4
X_2899_ u_uart_tx.clk_count\[3\] u_uart_tx.clk_count\[2\] _1442_ VGND VGND VPWR VPWR
+ _1446_ sky130_fd_sc_hd__and3_1
XFILLER_76_139 VGND VGND VPWR VPWR sky130_fd_sc_hd__fill_1
XFILLER_9_405 VPWR VGND VPWR VGND sky130_ef_sc_hd__decap_12
XFILLER_40_242 VGND VGND VPWR VPWR sky130_fd_sc_hd__decap_8
XFILLER_9_449 VPWR VGND VPWR VGND sky130_ef_sc_hd__decap_12
XFILLER_0_393 VPWR VGND VPWR VGND sky130_ef_sc_hd__decap_12
XTAP_TAPCELL_ROW_89_1051 VGND VPWR sky130_fd_sc_hd__tapvpwrvgnd_1
XFILLER_83_3 VPWR VGND VPWR VGND sky130_ef_sc_hd__decap_12
X_2822_ net606 net43 _1412_ VGND VGND VPWR VPWR _0476_ sky130_fd_sc_hd__mux2_1
X_2753_ u_parser.u_decoder.ascii_buf\[11\]\[5\] _1378_ _1379_ _1382_ VGND VGND VPWR
+ VPWR _1387_ sky130_fd_sc_hd__a211o_1
X_1704_ net40 _0770_ net42 VGND VGND VPWR VPWR _0771_ sky130_fd_sc_hd__o21ai_1
X_2684_ _1305_ _1361_ VGND VGND VPWR VPWR _1362_ sky130_fd_sc_hd__xnor2_1
X_1635_ u_uart_rx.state\[2\] _0702_ VGND VGND VPWR VPWR _0703_ sky130_fd_sc_hd__and2_1
X_3305_ clknet_leaf_62_clk _0141_ VGND VGND VPWR VPWR u_tx_fifo.mem\[13\]\[0\] sky130_fd_sc_hd__dfxtp_1
XFILLER_58_117 VPWR VGND VPWR VGND sky130_ef_sc_hd__decap_12
X_3236_ clknet_leaf_13_clk _0072_ VGND VGND VPWR VPWR u_rx_fifo.mem\[5\]\[3\] sky130_fd_sc_hd__dfxtp_1
X_3167_ net27 net341 _1586_ VGND VGND VPWR VPWR _0647_ sky130_fd_sc_hd__mux2_1
XFILLER_66_150 VGND VGND VPWR VPWR sky130_fd_sc_hd__fill_2
X_3098_ _0666_ _1550_ VGND VGND VPWR VPWR _1552_ sky130_fd_sc_hd__nor2_1
X_2118_ _0988_ _0995_ VGND VGND VPWR VPWR _0996_ sky130_fd_sc_hd__xnor2_1
XFILLER_27_537 VPWR VGND VPWR VGND sky130_ef_sc_hd__decap_12
XFILLER_81_142 VGND VGND VPWR VPWR sky130_fd_sc_hd__fill_1
XTAP_TAPCELL_ROW_37_554 VGND VPWR sky130_fd_sc_hd__tapvpwrvgnd_1
XFILLER_42_518 VGND VGND VPWR VPWR sky130_fd_sc_hd__fill_1
X_2049_ _0875_ _0886_ VGND VGND VPWR VPWR _0959_ sky130_fd_sc_hd__nor2_4
Xfanout13 net14 VGND VGND VPWR VPWR net13 sky130_fd_sc_hd__clkbuf_4
XFILLER_80_29 VGND VGND VPWR VPWR sky130_fd_sc_hd__decap_8
Xfanout24 _0919_ VGND VGND VPWR VPWR net24 sky130_fd_sc_hd__buf_1
Xfanout35 _0779_ VGND VGND VPWR VPWR net35 sky130_fd_sc_hd__clkbuf_4
Xfanout79 rx_fifo_in_data\[3\] VGND VGND VPWR VPWR net79 sky130_fd_sc_hd__buf_2
Xfanout57 _0883_ VGND VGND VPWR VPWR net57 sky130_fd_sc_hd__buf_2
Xfanout68 u_tx_fifo.rd_ptr\[0\] VGND VGND VPWR VPWR net68 sky130_fd_sc_hd__buf_4
XFILLER_6_408 VPWR VGND VPWR VGND sky130_ef_sc_hd__decap_12
XFILLER_13_78 VGND VGND VPWR VPWR sky130_fd_sc_hd__decap_6
XFILLER_89_27 VPWR VGND VPWR VGND sky130_ef_sc_hd__decap_12
Xhold471 u_uart_rx.state\[3\] VGND VGND VPWR VPWR net627 sky130_fd_sc_hd__dlygate4sd3_1
XPHY_EDGE_ROW_8_Left_102 VGND VGND VPWR VPWR sky130_fd_sc_hd__decap_3
XFILLER_1_113 VGND VGND VPWR VPWR sky130_fd_sc_hd__decap_3
Xhold460 u_parser.u_decoder.ascii_buf\[9\]\[7\] VGND VGND VPWR VPWR net616 sky130_fd_sc_hd__dlygate4sd3_1
Xhold493 u_tx_fifo.level\[1\] VGND VGND VPWR VPWR net649 sky130_fd_sc_hd__dlygate4sd3_1
Xhold482 u_uart_tx.clk_count\[11\] VGND VGND VPWR VPWR net638 sky130_fd_sc_hd__dlygate4sd3_1
XFILLER_77_415 VGND VGND VPWR VPWR sky130_fd_sc_hd__decap_6
XFILLER_92_429 VGND VGND VPWR VPWR sky130_fd_sc_hd__fill_1
XFILLER_54_41 VGND VGND VPWR VPWR sky130_fd_sc_hd__decap_8
XTAP_TAPCELL_ROW_0_190 VGND VPWR sky130_fd_sc_hd__tapvpwrvgnd_1
XFILLER_72_175 VGND VGND VPWR VPWR sky130_fd_sc_hd__fill_1
XFILLER_54_85 VGND VGND VPWR VPWR sky130_fd_sc_hd__decap_6
XTAP_TAPCELL_ROW_71_877 VGND VPWR sky130_fd_sc_hd__tapvpwrvgnd_1
Xclkload16 clknet_leaf_2_clk VGND VGND VPWR VPWR clkload16/Y sky130_fd_sc_hd__inv_8
Xclkload27 clknet_leaf_50_clk VGND VGND VPWR VPWR clkload27/Y sky130_fd_sc_hd__clkinv_4
Xclkload38 clknet_leaf_8_clk VGND VGND VPWR VPWR clkload38/Y sky130_fd_sc_hd__inv_4
Xclkload49 clknet_leaf_19_clk VGND VGND VPWR VPWR clkload49/Y sky130_fd_sc_hd__clkinv_8
XFILLER_5_441 VGND VGND VPWR VPWR sky130_fd_sc_hd__decap_6
XFILLER_5_485 VPWR VGND VPWR VGND sky130_ef_sc_hd__decap_12
XTAP_TAPCELL_ROW_79_955 VGND VPWR sky130_fd_sc_hd__tapvpwrvgnd_1
X_3021_ net76 net333 _1506_ VGND VGND VPWR VPWR _0581_ sky130_fd_sc_hd__mux2_1
XFILLER_91_495 VGND VGND VPWR VPWR sky130_fd_sc_hd__decap_8
XTAP_TAPCELL_ROW_34_524 VGND VPWR sky130_fd_sc_hd__tapvpwrvgnd_1
X_2805_ net585 net35 _1410_ VGND VGND VPWR VPWR _0461_ sky130_fd_sc_hd__mux2_1
X_3785_ clknet_leaf_27_clk _0603_ net139 VGND VGND VPWR VPWR u_uart_rx.sample_div_count\[5\]
+ sky130_fd_sc_hd__dfrtp_1
X_2736_ net36 net653 _1376_ VGND VGND VPWR VPWR _0426_ sky130_fd_sc_hd__mux2_1
X_2667_ _1205_ _1235_ VGND VGND VPWR VPWR _1348_ sky130_fd_sc_hd__xor2_1
X_1618_ u_uart_rx.sample_phase\[0\] u_uart_rx.sample_phase\[1\] u_uart_rx.sample_phase\[2\]
+ u_uart_rx.sample_phase\[3\] VGND VGND VPWR VPWR _0688_ sky130_fd_sc_hd__nand4_1
X_2598_ net455 _1293_ net13 VGND VGND VPWR VPWR _0371_ sky130_fd_sc_hd__mux2_1
XFILLER_59_426 VGND VGND VPWR VPWR sky130_fd_sc_hd__fill_1
XFILLER_46_109 VPWR VGND VPWR VGND sky130_ef_sc_hd__decap_12
X_3219_ clknet_leaf_13_clk _0055_ VGND VGND VPWR VPWR u_rx_fifo.mem\[7\]\[2\] sky130_fd_sc_hd__dfxtp_1
XFILLER_67_481 VGND VGND VPWR VPWR sky130_fd_sc_hd__decap_6
XFILLER_91_39 VPWR VGND VPWR VGND sky130_ef_sc_hd__decap_12
XFILLER_82_473 VGND VGND VPWR VPWR sky130_fd_sc_hd__decap_3
XFILLER_54_197 VGND VGND VPWR VPWR sky130_fd_sc_hd__decap_3
XFILLER_6_205 VGND VGND VPWR VPWR sky130_fd_sc_hd__decap_8
XFILLER_6_249 VGND VGND VPWR VPWR sky130_fd_sc_hd__decap_3
XFILLER_2_433 VPWR VGND VPWR VGND sky130_ef_sc_hd__decap_12
XFILLER_2_477 VPWR VGND VPWR VGND sky130_ef_sc_hd__decap_12
Xhold290 u_parser.u_decoder.decoded_payload\[33\] VGND VGND VPWR VPWR net446 sky130_fd_sc_hd__dlygate4sd3_1
XTAP_TAPCELL_ROW_76_925 VGND VPWR sky130_fd_sc_hd__tapvpwrvgnd_1
XFILLER_1_15 VPWR VGND VPWR VGND sky130_ef_sc_hd__decap_12
XFILLER_92_226 VGND VGND VPWR VPWR sky130_fd_sc_hd__decap_3
XTAP_TAPCELL_ROW_86_1021 VGND VPWR sky130_fd_sc_hd__tapvpwrvgnd_1
XFILLER_18_334 VGND VGND VPWR VPWR sky130_fd_sc_hd__decap_8
XFILLER_65_51 VGND VGND VPWR VPWR sky130_fd_sc_hd__decap_4
XFILLER_33_337 VGND VGND VPWR VPWR sky130_fd_sc_hd__fill_1
XFILLER_45_197 VGND VGND VPWR VPWR sky130_fd_sc_hd__fill_1
XFILLER_81_83 VGND VGND VPWR VPWR sky130_fd_sc_hd__decap_4
X_3570_ clknet_leaf_23_clk _0397_ net117 VGND VGND VPWR VPWR u_parser.u_decoder.ascii_buf\[6\]\[5\]
+ sky130_fd_sc_hd__dfrtp_1
X_2521_ u_parser.u_decoder.ascii_buf\[7\]\[0\] u_parser.u_decoder.ascii_buf\[7\]\[1\]
+ _1224_ u_parser.u_decoder.ascii_buf\[7\]\[2\] VGND VGND VPWR VPWR _1234_ sky130_fd_sc_hd__a31o_1
XFILLER_46_3 VPWR VGND VPWR VGND sky130_ef_sc_hd__decap_12
X_2452_ u_parser.u_decoder.timeout_count\[8\] _1179_ _1180_ VGND VGND VPWR VPWR _1181_
+ sky130_fd_sc_hd__and3_1
XPHY_EDGE_ROW_18_Right_18 VGND VGND VPWR VPWR sky130_fd_sc_hd__decap_3
X_2383_ tag_raw\[36\] net458 net15 VGND VGND VPWR VPWR _0309_ sky130_fd_sc_hd__mux2_1
X_3004_ net205 net21 _1504_ VGND VGND VPWR VPWR _0566_ sky130_fd_sc_hd__mux2_1
XFILLER_64_451 VGND VGND VPWR VPWR sky130_fd_sc_hd__fill_2
XTAP_TAPCELL_ROW_19_384 VGND VPWR sky130_fd_sc_hd__tapvpwrvgnd_1
XPHY_EDGE_ROW_27_Right_27 VGND VGND VPWR VPWR sky130_fd_sc_hd__decap_3
XFILLER_36_197 VGND VGND VPWR VPWR sky130_fd_sc_hd__decap_4
X_3837_ clknet_leaf_64_clk _0653_ VGND VGND VPWR VPWR u_tx_fifo.mem\[11\]\[6\] sky130_fd_sc_hd__dfxtp_1
X_3768_ clknet_leaf_15_clk _0586_ VGND VGND VPWR VPWR u_rx_fifo.mem\[2\]\[1\] sky130_fd_sc_hd__dfxtp_1
X_2719_ u_parser.u_decoder.ascii_buf\[7\]\[3\] net44 _1374_ VGND VGND VPWR VPWR _0411_
+ sky130_fd_sc_hd__mux2_1
XFILLER_10_46 VGND VGND VPWR VPWR sky130_fd_sc_hd__fill_1
X_3699_ clknet_leaf_49_clk _0523_ net102 VGND VGND VPWR VPWR u_uart_tx.clk_count\[6\]
+ sky130_fd_sc_hd__dfrtp_1
XPHY_EDGE_ROW_36_Right_36 VGND VGND VPWR VPWR sky130_fd_sc_hd__decap_3
XFILLER_59_223 VGND VGND VPWR VPWR sky130_fd_sc_hd__fill_1
XFILLER_55_440 VGND VGND VPWR VPWR sky130_fd_sc_hd__decap_8
XFILLER_35_43 VGND VGND VPWR VPWR sky130_fd_sc_hd__fill_1
XPHY_EDGE_ROW_45_Right_45 VGND VGND VPWR VPWR sky130_fd_sc_hd__decap_3
XFILLER_70_421 VPWR VGND VPWR VGND sky130_ef_sc_hd__decap_12
XTAP_TAPCELL_ROW_81_972 VGND VPWR sky130_fd_sc_hd__tapvpwrvgnd_1
XFILLER_30_307 VGND VGND VPWR VPWR sky130_fd_sc_hd__fill_1
XFILLER_30_318 VGND VGND VPWR VPWR sky130_fd_sc_hd__decap_3
XFILLER_7_503 VGND VGND VPWR VPWR sky130_fd_sc_hd__fill_1
XPHY_EDGE_ROW_54_Right_54 VGND VGND VPWR VPWR sky130_fd_sc_hd__decap_3
XTAP_TAPCELL_ROW_92_1080 VGND VPWR sky130_fd_sc_hd__tapvpwrvgnd_1
XFILLER_78_510 VPWR VGND VPWR VGND sky130_ef_sc_hd__decap_12
XPHY_EDGE_ROW_63_Right_63 VGND VGND VPWR VPWR sky130_fd_sc_hd__decap_3
XFILLER_46_473 VGND VGND VPWR VPWR sky130_fd_sc_hd__decap_3
XTAP_TAPCELL_ROW_16_354 VGND VPWR sky130_fd_sc_hd__tapvpwrvgnd_1
XFILLER_33_178 VGND VGND VPWR VPWR sky130_fd_sc_hd__decap_4
X_1952_ net75 net346 _0944_ VGND VGND VPWR VPWR _0074_ sky130_fd_sc_hd__mux2_1
X_1883_ u_parser.u_packet_encoder.tag_latched\[9\] _0894_ _0896_ u_parser.u_packet_encoder.tag_latched\[33\]
+ _0911_ VGND VGND VPWR VPWR _0912_ sky130_fd_sc_hd__a221o_1
X_3622_ clknet_leaf_40_clk _0449_ net106 VGND VGND VPWR VPWR u_parser.u_decoder.ascii_buf\[1\]\[1\]
+ sky130_fd_sc_hd__dfrtp_2
XPHY_EDGE_ROW_72_Right_72 VGND VGND VPWR VPWR sky130_fd_sc_hd__decap_3
X_3553_ clknet_leaf_56_clk _0380_ net99 VGND VGND VPWR VPWR u_parser.u_decoder.decoded_payload\[36\]
+ sky130_fd_sc_hd__dfrtp_1
X_2504_ net489 _1220_ net7 VGND VGND VPWR VPWR _0350_ sky130_fd_sc_hd__mux2_1
X_3484_ clknet_leaf_56_clk _0311_ net97 VGND VGND VPWR VPWR tag_raw\[38\] sky130_fd_sc_hd__dfrtp_4
X_2435_ net4 _1167_ _1169_ VGND VGND VPWR VPWR _0332_ sky130_fd_sc_hd__and3_1
XFILLER_69_554 VGND VGND VPWR VPWR sky130_fd_sc_hd__fill_1
X_2366_ tag_raw\[19\] net454 net18 VGND VGND VPWR VPWR _0292_ sky130_fd_sc_hd__mux2_1
XFILLER_84_524 VGND VGND VPWR VPWR sky130_fd_sc_hd__decap_8
XPHY_EDGE_ROW_81_Right_81 VGND VGND VPWR VPWR sky130_fd_sc_hd__decap_3
X_2297_ u_tx_fifo.mem\[8\]\[4\] u_tx_fifo.mem\[9\]\[4\] u_tx_fifo.mem\[10\]\[4\] u_tx_fifo.mem\[11\]\[4\]
+ net67 net63 VGND VGND VPWR VPWR _1103_ sky130_fd_sc_hd__mux4_1
XFILLER_24_134 VGND VGND VPWR VPWR sky130_fd_sc_hd__decap_6
XFILLER_52_421 VGND VGND VPWR VPWR sky130_fd_sc_hd__decap_6
XFILLER_64_281 VGND VGND VPWR VPWR sky130_fd_sc_hd__decap_3
XPHY_EDGE_ROW_90_Right_90 VGND VGND VPWR VPWR sky130_fd_sc_hd__decap_3
XTAP_TAPCELL_ROW_50_677 VGND VPWR sky130_fd_sc_hd__tapvpwrvgnd_1
XFILLER_79_329 VGND VGND VPWR VPWR sky130_fd_sc_hd__decap_6
XTAP_TAPCELL_ROW_58_755 VGND VPWR sky130_fd_sc_hd__tapvpwrvgnd_1
XFILLER_46_53 VPWR VGND VPWR VGND sky130_ef_sc_hd__decap_12
XFILLER_46_97 VPWR VGND VPWR VGND sky130_ef_sc_hd__decap_12
XTAP_TAPCELL_ROW_13_324 VGND VPWR sky130_fd_sc_hd__tapvpwrvgnd_1
XFILLER_43_498 VGND VGND VPWR VPWR sky130_fd_sc_hd__decap_6
XFILLER_62_41 VGND VGND VPWR VPWR sky130_fd_sc_hd__decap_8
XFILLER_70_273 VGND VGND VPWR VPWR sky130_fd_sc_hd__decap_3
X_2220_ tag_raw\[27\] net516 net57 VGND VGND VPWR VPWR _0224_ sky130_fd_sc_hd__mux2_1
XFILLER_87_82 VGND VGND VPWR VPWR sky130_fd_sc_hd__decap_6
XFILLER_93_321 VPWR VGND VPWR VGND sky130_ef_sc_hd__decap_12
X_2151_ _1012_ _1028_ VGND VGND VPWR VPWR _1029_ sky130_fd_sc_hd__xnor2_2
XFILLER_93_365 VPWR VGND VPWR VGND sky130_ef_sc_hd__decap_12
XFILLER_38_259 VGND VGND VPWR VPWR sky130_fd_sc_hd__fill_1
X_2082_ net40 u_parser.u_decoder.ascii_buf\[11\]\[0\] _0967_ VGND VGND VPWR VPWR _0181_
+ sky130_fd_sc_hd__mux2_1
XFILLER_34_454 VGND VGND VPWR VPWR sky130_fd_sc_hd__fill_1
X_2984_ _0668_ net481 VGND VGND VPWR VPWR _0552_ sky130_fd_sc_hd__and2_1
X_1935_ net70 net313 _0874_ VGND VGND VPWR VPWR _0060_ sky130_fd_sc_hd__mux2_1
X_1866_ _0893_ _0895_ VGND VGND VPWR VPWR _0896_ sky130_fd_sc_hd__nor2_4
X_1797_ net587 _0852_ VGND VGND VPWR VPWR _0011_ sky130_fd_sc_hd__xor2_1
X_3605_ clknet_leaf_36_clk _0432_ net133 VGND VGND VPWR VPWR u_parser.u_decoder.decoded_checksum_rx\[0\]
+ sky130_fd_sc_hd__dfrtp_1
X_3536_ clknet_leaf_45_clk _0363_ net109 VGND VGND VPWR VPWR u_parser.u_decoder.decoded_payload\[19\]
+ sky130_fd_sc_hd__dfrtp_1
X_3467_ clknet_leaf_57_clk _0294_ net97 VGND VGND VPWR VPWR tag_raw\[21\] sky130_fd_sc_hd__dfrtp_1
X_3398_ clknet_leaf_52_clk _0231_ net94 VGND VGND VPWR VPWR u_parser.u_packet_encoder.tag_latched\[34\]
+ sky130_fd_sc_hd__dfrtp_1
X_2418_ u_parser.u_decoder.timeout_count\[1\] u_parser.u_decoder.timeout_count\[0\]
+ _1152_ u_parser.u_decoder.timeout_count\[2\] VGND VGND VPWR VPWR _1158_ sky130_fd_sc_hd__a31o_1
X_2349_ tag_raw\[2\] net407 net17 VGND VGND VPWR VPWR _0275_ sky130_fd_sc_hd__mux2_1
XFILLER_29_204 VPWR VGND VPWR VGND sky130_ef_sc_hd__decap_12
XFILLER_29_259 VGND VGND VPWR VPWR sky130_fd_sc_hd__fill_1
XFILLER_84_365 VGND VGND VPWR VPWR sky130_fd_sc_hd__fill_1
XTAP_TAPCELL_ROW_55_725 VGND VPWR sky130_fd_sc_hd__tapvpwrvgnd_1
XFILLER_37_281 VGND VGND VPWR VPWR sky130_fd_sc_hd__fill_1
XPHY_EDGE_ROW_0_Right_0 VGND VGND VPWR VPWR sky130_fd_sc_hd__decap_3
XFILLER_40_457 VGND VGND VPWR VPWR sky130_fd_sc_hd__fill_1
XFILLER_4_325 VGND VGND VPWR VPWR sky130_fd_sc_hd__decap_4
XFILLER_0_553 VGND VGND VPWR VPWR sky130_fd_sc_hd__fill_2
XFILLER_75_321 VGND VGND VPWR VPWR sky130_fd_sc_hd__decap_6
XFILLER_57_85 VGND VGND VPWR VPWR sky130_fd_sc_hd__fill_2
XFILLER_57_96 VGND VGND VPWR VPWR sky130_fd_sc_hd__decap_6
XFILLER_75_332 VGND VGND VPWR VPWR sky130_fd_sc_hd__decap_4
XFILLER_35_218 VGND VGND VPWR VPWR sky130_fd_sc_hd__decap_6
XFILLER_16_421 VGND VGND VPWR VPWR sky130_fd_sc_hd__decap_6
XPHY_EDGE_ROW_35_Left_129 VGND VGND VPWR VPWR sky130_fd_sc_hd__decap_3
X_1720_ u_parser.u_decoder.timeout_count\[3\] u_parser.u_decoder.timeout_count\[4\]
+ _0786_ u_parser.u_decoder.timeout_count\[5\] VGND VGND VPWR VPWR _0787_ sky130_fd_sc_hd__a31o_1
Xhold108 u_rx_fifo.mem\[0\]\[1\] VGND VGND VPWR VPWR net264 sky130_fd_sc_hd__dlygate4sd3_1
XPHY_EDGE_ROW_44_Left_138 VGND VGND VPWR VPWR sky130_fd_sc_hd__decap_3
X_1651_ _0712_ _0714_ _0717_ _0671_ VGND VGND VPWR VPWR _0718_ sky130_fd_sc_hd__a22o_2
Xhold119 u_tx_fifo.mem\[11\]\[1\] VGND VGND VPWR VPWR net275 sky130_fd_sc_hd__dlygate4sd3_1
X_3321_ clknet_leaf_21_clk _0157_ VGND VGND VPWR VPWR u_rx_fifo.mem\[12\]\[0\] sky130_fd_sc_hd__dfxtp_1
X_3252_ clknet_leaf_1_clk _0088_ VGND VGND VPWR VPWR u_tx_fifo.mem\[6\]\[3\] sky130_fd_sc_hd__dfxtp_1
X_2203_ tag_raw\[10\] net505 net56 VGND VGND VPWR VPWR _0207_ sky130_fd_sc_hd__mux2_1
XFILLER_39_513 VGND VGND VPWR VPWR sky130_fd_sc_hd__fill_1
X_3183_ clknet_leaf_16_clk _0019_ net120 VGND VGND VPWR VPWR u_rx_fifo.wr_ptr\[3\]
+ sky130_fd_sc_hd__dfrtp_4
X_2134_ tag_raw\[0\] _1011_ VGND VGND VPWR VPWR _1012_ sky130_fd_sc_hd__xor2_1
XFILLER_93_173 VGND VGND VPWR VPWR sky130_fd_sc_hd__decap_8
XFILLER_81_302 VGND VGND VPWR VPWR sky130_fd_sc_hd__decap_8
XPHY_EDGE_ROW_53_Left_147 VGND VGND VPWR VPWR sky130_fd_sc_hd__decap_3
XFILLER_66_365 VGND VGND VPWR VPWR sky130_fd_sc_hd__fill_1
XFILLER_93_195 VGND VGND VPWR VPWR sky130_fd_sc_hd__fill_1
X_2065_ net163 net19 _0960_ VGND VGND VPWR VPWR _0171_ sky130_fd_sc_hd__mux2_1
XTAP_TAPCELL_ROW_60_772 VGND VPWR sky130_fd_sc_hd__tapvpwrvgnd_1
X_2967_ net565 _1486_ _1488_ VGND VGND VPWR VPWR _0545_ sky130_fd_sc_hd__o21a_1
X_2898_ _1444_ _1445_ VGND VGND VPWR VPWR _0519_ sky130_fd_sc_hd__nor2_1
X_1918_ net29 net370 _0892_ VGND VGND VPWR VPWR _0044_ sky130_fd_sc_hd__mux2_1
XPHY_EDGE_ROW_62_Left_156 VGND VGND VPWR VPWR sky130_fd_sc_hd__decap_3
X_1849_ u_rx_fifo.wr_ptr\[3\] u_rx_fifo.wr_ptr\[2\] VGND VGND VPWR VPWR _0887_ sky130_fd_sc_hd__or2_2
XFILLER_78_29 VGND VGND VPWR VPWR sky130_fd_sc_hd__decap_6
X_3519_ clknet_leaf_47_clk _0346_ net105 VGND VGND VPWR VPWR u_parser.u_decoder.decoded_payload\[2\]
+ sky130_fd_sc_hd__dfrtp_1
XTAP_TAPCELL_ROW_68_850 VGND VPWR sky130_fd_sc_hd__tapvpwrvgnd_1
XPHY_EDGE_ROW_71_Left_165 VGND VGND VPWR VPWR sky130_fd_sc_hd__decap_3
XFILLER_27_55 VGND VGND VPWR VPWR sky130_fd_sc_hd__fill_1
XFILLER_27_66 VGND VGND VPWR VPWR sky130_fd_sc_hd__decap_6
XFILLER_72_324 VGND VGND VPWR VPWR sky130_fd_sc_hd__fill_2
XFILLER_13_457 VPWR VGND VPWR VGND sky130_ef_sc_hd__decap_12
XFILLER_9_417 VPWR VGND VPWR VGND sky130_ef_sc_hd__decap_12
XFILLER_40_221 VPWR VGND VPWR VGND sky130_ef_sc_hd__decap_12
XPHY_EDGE_ROW_80_Left_174 VGND VGND VPWR VPWR sky130_fd_sc_hd__decap_3
Xclkbuf_leaf_20_clk clknet_3_5__leaf_clk VGND VGND VPWR VPWR clknet_leaf_20_clk sky130_fd_sc_hd__clkbuf_8
XFILLER_4_15 VPWR VGND VPWR VGND sky130_ef_sc_hd__decap_12
XFILLER_0_361 VGND VGND VPWR VPWR sky130_fd_sc_hd__decap_3
XFILLER_48_365 VGND VGND VPWR VPWR sky130_fd_sc_hd__decap_3
XFILLER_84_72 VGND VGND VPWR VPWR sky130_fd_sc_hd__decap_3
X_2821_ u_parser.u_decoder.ascii_buf\[4\]\[3\] net44 _1412_ VGND VGND VPWR VPWR _0475_
+ sky130_fd_sc_hd__mux2_1
XFILLER_76_3 VPWR VGND VPWR VGND sky130_ef_sc_hd__decap_12
XFILLER_31_298 VGND VGND VPWR VPWR sky130_fd_sc_hd__fill_1
Xclkbuf_leaf_11_clk clknet_3_4__leaf_clk VGND VGND VPWR VPWR clknet_leaf_11_clk sky130_fd_sc_hd__clkbuf_8
X_2752_ _0675_ net12 VGND VGND VPWR VPWR _1386_ sky130_fd_sc_hd__nor2_1
X_1703_ net38 net36 VGND VGND VPWR VPWR _0770_ sky130_fd_sc_hd__or2_1
X_2683_ _1359_ _1360_ VGND VGND VPWR VPWR _1361_ sky130_fd_sc_hd__xnor2_1
X_1634_ _0664_ _0668_ u_uart_rx.state\[0\] _0698_ net627 VGND VGND VPWR VPWR _0006_
+ sky130_fd_sc_hd__a32o_1
X_3304_ clknet_leaf_66_clk _0140_ VGND VGND VPWR VPWR u_tx_fifo.mem\[14\]\[7\] sky130_fd_sc_hd__dfxtp_1
XFILLER_58_129 VGND VGND VPWR VPWR sky130_fd_sc_hd__decap_8
X_3235_ clknet_leaf_13_clk _0071_ VGND VGND VPWR VPWR u_rx_fifo.mem\[5\]\[2\] sky130_fd_sc_hd__dfxtp_1
X_3166_ u_tx_fifo.wr_ptr\[2\] u_tx_fifo.wr_ptr\[3\] _0889_ VGND VGND VPWR VPWR _1586_
+ sky130_fd_sc_hd__nand3b_4
X_3097_ _1550_ _1551_ VGND VGND VPWR VPWR _0612_ sky130_fd_sc_hd__nor2_1
X_2117_ tag_raw\[13\] _0994_ VGND VGND VPWR VPWR _0995_ sky130_fd_sc_hd__xor2_1
XFILLER_27_549 VGND VGND VPWR VPWR sky130_fd_sc_hd__decap_6
XTAP_TAPCELL_ROW_65_820 VGND VPWR sky130_fd_sc_hd__tapvpwrvgnd_1
XFILLER_66_195 VGND VGND VPWR VPWR sky130_fd_sc_hd__fill_1
X_2048_ net242 net71 _0958_ VGND VGND VPWR VPWR _0156_ sky130_fd_sc_hd__mux2_1
XTAP_TAPCELL_ROW_37_555 VGND VPWR sky130_fd_sc_hd__tapvpwrvgnd_1
Xfanout25 _0913_ VGND VGND VPWR VPWR net25 sky130_fd_sc_hd__clkbuf_2
Xfanout14 _1191_ VGND VGND VPWR VPWR net14 sky130_fd_sc_hd__buf_4
Xfanout36 _0768_ VGND VGND VPWR VPWR net36 sky130_fd_sc_hd__clkbuf_4
Xfanout58 _0670_ VGND VGND VPWR VPWR net58 sky130_fd_sc_hd__clkbuf_4
Xfanout69 u_tx_fifo.rd_ptr\[0\] VGND VGND VPWR VPWR net69 sky130_fd_sc_hd__clkbuf_4
XFILLER_89_39 VPWR VGND VPWR VGND sky130_ef_sc_hd__decap_12
Xhold461 u_uart_rx.low_count\[4\] VGND VGND VPWR VPWR net617 sky130_fd_sc_hd__dlygate4sd3_1
Xhold450 u_parser.u_decoder.ascii_buf\[4\]\[4\] VGND VGND VPWR VPWR net606 sky130_fd_sc_hd__dlygate4sd3_1
Xhold472 u_parser.u_decoder.ascii_buf\[10\]\[6\] VGND VGND VPWR VPWR net628 sky130_fd_sc_hd__dlygate4sd3_1
Xhold494 u_tx_fifo.wr_ptr\[0\] VGND VGND VPWR VPWR net650 sky130_fd_sc_hd__dlygate4sd3_1
Xhold483 u_parser.u_decoder.ascii_buf\[4\]\[2\] VGND VGND VPWR VPWR net639 sky130_fd_sc_hd__dlygate4sd3_1
XFILLER_1_169 VPWR VGND VPWR VGND sky130_ef_sc_hd__decap_12
XFILLER_77_449 VGND VGND VPWR VPWR sky130_fd_sc_hd__decap_4
XFILLER_45_335 VGND VGND VPWR VPWR sky130_fd_sc_hd__fill_1
XFILLER_45_346 VGND VGND VPWR VPWR sky130_fd_sc_hd__fill_1
XFILLER_60_338 VGND VGND VPWR VPWR sky130_fd_sc_hd__fill_1
XTAP_TAPCELL_ROW_0_191 VGND VPWR sky130_fd_sc_hd__tapvpwrvgnd_1
XTAP_TAPCELL_ROW_71_878 VGND VPWR sky130_fd_sc_hd__tapvpwrvgnd_1
XFILLER_70_41 VPWR VGND VPWR VGND sky130_ef_sc_hd__decap_12
Xclkload17 clknet_leaf_3_clk VGND VGND VPWR VPWR clkload17/Y sky130_fd_sc_hd__inv_6
XFILLER_70_63 VGND VGND VPWR VPWR sky130_fd_sc_hd__decap_6
Xclkload28 clknet_leaf_51_clk VGND VGND VPWR VPWR clkload28/Y sky130_fd_sc_hd__clkinv_8
Xclkload39 clknet_leaf_9_clk VGND VGND VPWR VPWR clkload39/Y sky130_fd_sc_hd__inv_8
XFILLER_5_497 VGND VGND VPWR VPWR sky130_fd_sc_hd__decap_6
XTAP_TAPCELL_ROW_8_280 VGND VPWR sky130_fd_sc_hd__tapvpwrvgnd_1
XTAP_TAPCELL_ROW_79_956 VGND VPWR sky130_fd_sc_hd__tapvpwrvgnd_1
Xclkbuf_leaf_0_clk clknet_3_0__leaf_clk VGND VGND VPWR VPWR clknet_leaf_0_clk sky130_fd_sc_hd__clkbuf_8
X_3020_ net78 net393 _1506_ VGND VGND VPWR VPWR _0580_ sky130_fd_sc_hd__mux2_1
XFILLER_48_195 VGND VGND VPWR VPWR sky130_fd_sc_hd__fill_1
XTAP_TAPCELL_ROW_34_525 VGND VPWR sky130_fd_sc_hd__tapvpwrvgnd_1
XFILLER_51_305 VGND VGND VPWR VPWR sky130_fd_sc_hd__decap_6
XFILLER_32_530 VGND VGND VPWR VPWR sky130_fd_sc_hd__fill_2
X_2804_ net566 net43 _1410_ VGND VGND VPWR VPWR _0460_ sky130_fd_sc_hd__mux2_1
X_3784_ clknet_leaf_27_clk _0602_ net138 VGND VGND VPWR VPWR u_uart_rx.sample_div_count\[4\]
+ sky130_fd_sc_hd__dfrtp_1
X_2735_ net38 u_parser.u_decoder.ascii_buf\[8\]\[1\] _1376_ VGND VGND VPWR VPWR _0425_
+ sky130_fd_sc_hd__mux2_1
X_2666_ _1263_ _1292_ VGND VGND VPWR VPWR _1347_ sky130_fd_sc_hd__xor2_1
X_1617_ u_uart_rx.sample_phase\[0\] u_uart_rx.sample_phase\[1\] VGND VGND VPWR VPWR
+ _0687_ sky130_fd_sc_hd__nand2_1
X_2597_ u_parser.u_decoder.ascii_buf\[3\]\[3\] _1282_ _1285_ VGND VGND VPWR VPWR _1293_
+ sky130_fd_sc_hd__a21o_1
X_3218_ clknet_leaf_16_clk _0054_ VGND VGND VPWR VPWR u_rx_fifo.mem\[7\]\[1\] sky130_fd_sc_hd__dfxtp_1
XFILLER_39_140 VGND VGND VPWR VPWR sky130_fd_sc_hd__fill_1
X_3149_ u_uart_rx.bit_index\[2\] _1575_ u_uart_rx.rx_shift\[4\] VGND VGND VPWR VPWR
+ _1581_ sky130_fd_sc_hd__a21boi_1
XFILLER_42_305 VGND VGND VPWR VPWR sky130_fd_sc_hd__decap_3
XFILLER_35_390 VGND VGND VPWR VPWR sky130_fd_sc_hd__fill_2
XFILLER_6_228 VGND VGND VPWR VPWR sky130_fd_sc_hd__fill_2
XFILLER_2_401 VPWR VGND VPWR VGND sky130_ef_sc_hd__decap_12
Xhold280 u_parser.u_decoder.decoded_payload\[0\] VGND VGND VPWR VPWR net436 sky130_fd_sc_hd__dlygate4sd3_1
XFILLER_6_3 VPWR VGND VPWR VGND sky130_ef_sc_hd__decap_12
XFILLER_2_445 VPWR VGND VPWR VGND sky130_ef_sc_hd__decap_12
XFILLER_77_213 VGND VGND VPWR VPWR sky130_fd_sc_hd__fill_1
Xhold291 u_uart_tx.tx_data\[0\] VGND VGND VPWR VPWR net447 sky130_fd_sc_hd__dlygate4sd3_1
XFILLER_2_489 VPWR VGND VPWR VGND sky130_ef_sc_hd__decap_12
XTAP_TAPCELL_ROW_76_926 VGND VPWR sky130_fd_sc_hd__tapvpwrvgnd_1
XTAP_TAPCELL_ROW_5_250 VGND VPWR sky130_fd_sc_hd__tapvpwrvgnd_1
XFILLER_1_27 VPWR VGND VPWR VGND sky130_ef_sc_hd__decap_12
XFILLER_58_460 VPWR VGND VPWR VGND sky130_ef_sc_hd__decap_12
XTAP_TAPCELL_ROW_86_1022 VGND VPWR sky130_fd_sc_hd__tapvpwrvgnd_1
XFILLER_41_393 VPWR VGND VPWR VGND sky130_ef_sc_hd__decap_12
X_2520_ net453 _1233_ net10 VGND VGND VPWR VPWR _0353_ sky130_fd_sc_hd__mux2_1
X_2451_ u_parser.u_decoder.timeout_count\[10\] u_parser.u_decoder.timeout_count\[7\]
+ u_parser.u_decoder.timeout_count\[6\] VGND VGND VPWR VPWR _1180_ sky130_fd_sc_hd__and3_1
XFILLER_39_3 VPWR VGND VPWR VGND sky130_ef_sc_hd__decap_12
X_2382_ tag_raw\[35\] net465 _1140_ VGND VGND VPWR VPWR _0308_ sky130_fd_sc_hd__mux2_1
XFILLER_68_213 VGND VGND VPWR VPWR sky130_fd_sc_hd__decap_3
XFILLER_56_419 VGND VGND VPWR VPWR sky130_fd_sc_hd__fill_1
X_3003_ net172 net31 _1504_ VGND VGND VPWR VPWR _0565_ sky130_fd_sc_hd__mux2_1
XFILLER_36_121 VGND VGND VPWR VPWR sky130_fd_sc_hd__fill_1
XTAP_TAPCELL_ROW_47_650 VGND VPWR sky130_fd_sc_hd__tapvpwrvgnd_1
XTAP_TAPCELL_ROW_19_385 VGND VPWR sky130_fd_sc_hd__tapvpwrvgnd_1
XFILLER_51_113 VPWR VGND VPWR VGND sky130_ef_sc_hd__decap_12
XFILLER_20_533 VPWR VGND VPWR VGND sky130_ef_sc_hd__decap_12
X_3836_ clknet_leaf_65_clk _0652_ VGND VGND VPWR VPWR u_tx_fifo.mem\[11\]\[5\] sky130_fd_sc_hd__dfxtp_1
X_3767_ clknet_leaf_14_clk _0585_ VGND VGND VPWR VPWR u_rx_fifo.mem\[2\]\[0\] sky130_fd_sc_hd__dfxtp_1
X_2718_ u_parser.u_decoder.ascii_buf\[7\]\[2\] net37 _1374_ VGND VGND VPWR VPWR _0410_
+ sky130_fd_sc_hd__mux2_1
X_3698_ clknet_leaf_49_clk _0522_ net92 VGND VGND VPWR VPWR u_uart_tx.clk_count\[5\]
+ sky130_fd_sc_hd__dfrtp_1
X_2649_ _1333_ _1334_ VGND VGND VPWR VPWR _1335_ sky130_fd_sc_hd__and2_1
XFILLER_87_500 VGND VGND VPWR VPWR sky130_fd_sc_hd__decap_4
XFILLER_86_29 VGND VGND VPWR VPWR sky130_fd_sc_hd__decap_8
XFILLER_59_202 VGND VGND VPWR VPWR sky130_fd_sc_hd__decap_6
XFILLER_47_419 VGND VGND VPWR VPWR sky130_fd_sc_hd__fill_1
XTAP_TAPCELL_ROW_2_220 VGND VPWR sky130_fd_sc_hd__tapvpwrvgnd_1
XFILLER_74_227 VGND VGND VPWR VPWR sky130_fd_sc_hd__fill_2
XFILLER_27_165 VGND VGND VPWR VPWR sky130_fd_sc_hd__decap_3
XFILLER_70_400 VPWR VGND VPWR VGND sky130_ef_sc_hd__decap_12
XFILLER_70_433 VPWR VGND VPWR VGND sky130_ef_sc_hd__decap_12
XTAP_TAPCELL_ROW_81_973 VGND VPWR sky130_fd_sc_hd__tapvpwrvgnd_1
XFILLER_70_477 VGND VGND VPWR VPWR sky130_fd_sc_hd__fill_2
XFILLER_23_360 VGND VGND VPWR VPWR sky130_fd_sc_hd__fill_1
XFILLER_2_253 VGND VGND VPWR VPWR sky130_fd_sc_hd__fill_2
XFILLER_78_522 VGND VGND VPWR VPWR sky130_fd_sc_hd__fill_1
XFILLER_18_176 VGND VGND VPWR VPWR sky130_fd_sc_hd__fill_2
XFILLER_46_485 VPWR VGND VPWR VGND sky130_ef_sc_hd__decap_12
XFILLER_33_113 VGND VGND VPWR VPWR sky130_fd_sc_hd__decap_4
XTAP_TAPCELL_ROW_44_620 VGND VPWR sky130_fd_sc_hd__tapvpwrvgnd_1
XFILLER_92_94 VGND VGND VPWR VPWR sky130_fd_sc_hd__fill_1
XTAP_TAPCELL_ROW_16_355 VGND VPWR sky130_fd_sc_hd__tapvpwrvgnd_1
XFILLER_21_319 VGND VGND VPWR VPWR sky130_fd_sc_hd__decap_4
X_1951_ net77 net399 _0944_ VGND VGND VPWR VPWR _0073_ sky130_fd_sc_hd__mux2_1
X_1882_ _0878_ _0905_ _0904_ VGND VGND VPWR VPWR _0911_ sky130_fd_sc_hd__o21ai_2
X_3621_ clknet_leaf_41_clk _0448_ net107 VGND VGND VPWR VPWR u_parser.u_decoder.ascii_buf\[1\]\[0\]
+ sky130_fd_sc_hd__dfrtp_1
X_3552_ clknet_leaf_40_clk _0379_ net106 VGND VGND VPWR VPWR u_parser.u_decoder.decoded_payload\[35\]
+ sky130_fd_sc_hd__dfrtp_1
X_2503_ _1216_ _1219_ VGND VGND VPWR VPWR _1220_ sky130_fd_sc_hd__and2_1
X_3483_ clknet_leaf_55_clk _0310_ net99 VGND VGND VPWR VPWR tag_raw\[37\] sky130_fd_sc_hd__dfrtp_4
X_2434_ _1168_ VGND VGND VPWR VPWR _1169_ sky130_fd_sc_hd__inv_2
X_2365_ tag_raw\[18\] net450 net17 VGND VGND VPWR VPWR _0291_ sky130_fd_sc_hd__mux2_1
X_2296_ _1100_ _1101_ net61 VGND VGND VPWR VPWR _1102_ sky130_fd_sc_hd__mux2_1
XFILLER_52_477 VGND VGND VPWR VPWR sky130_fd_sc_hd__decap_6
X_3819_ clknet_leaf_18_clk _0635_ net121 VGND VGND VPWR VPWR u_uart_rx.rx_shift\[4\]
+ sky130_fd_sc_hd__dfrtp_1
XFILLER_20_363 VGND VGND VPWR VPWR sky130_fd_sc_hd__fill_1
XTAP_TAPCELL_ROW_50_678 VGND VPWR sky130_fd_sc_hd__tapvpwrvgnd_1
XFILLER_75_525 VPWR VGND VPWR VGND sky130_ef_sc_hd__decap_12
XFILLER_47_205 VGND VGND VPWR VPWR sky130_fd_sc_hd__fill_2
XFILLER_47_216 VGND VGND VPWR VPWR sky130_fd_sc_hd__fill_2
XTAP_TAPCELL_ROW_58_756 VGND VPWR sky130_fd_sc_hd__tapvpwrvgnd_1
XFILLER_46_65 VPWR VGND VPWR VGND sky130_ef_sc_hd__decap_12
XFILLER_15_113 VGND VGND VPWR VPWR sky130_fd_sc_hd__decap_4
XFILLER_70_296 VPWR VGND VPWR VGND sky130_ef_sc_hd__decap_12
XTAP_TAPCELL_ROW_13_325 VGND VPWR sky130_fd_sc_hd__tapvpwrvgnd_1
XFILLER_7_323 VGND VGND VPWR VPWR sky130_fd_sc_hd__fill_1
XFILLER_7_15 VPWR VGND VPWR VGND sky130_ef_sc_hd__decap_12
XFILLER_78_385 VGND VGND VPWR VPWR sky130_fd_sc_hd__fill_1
X_2150_ _1018_ _1027_ VGND VGND VPWR VPWR _1028_ sky130_fd_sc_hd__xnor2_1
XFILLER_93_333 VGND VGND VPWR VPWR sky130_fd_sc_hd__decap_3
X_2081_ _0963_ net5 VGND VGND VPWR VPWR _0967_ sky130_fd_sc_hd__nand2_4
XFILLER_93_377 VPWR VGND VPWR VGND sky130_ef_sc_hd__decap_12
XFILLER_46_260 VPWR VGND VPWR VGND sky130_ef_sc_hd__decap_12
XTAP_TAPCELL_ROW_29_480 VGND VPWR sky130_fd_sc_hd__tapvpwrvgnd_1
XFILLER_34_477 VPWR VGND VPWR VGND sky130_ef_sc_hd__decap_12
X_2983_ _0668_ net440 VGND VGND VPWR VPWR _0551_ sky130_fd_sc_hd__and2_1
XFILLER_21_105 VGND VGND VPWR VPWR sky130_fd_sc_hd__fill_1
X_1934_ net72 net412 _0874_ VGND VGND VPWR VPWR _0059_ sky130_fd_sc_hd__mux2_1
X_1865_ u_parser.u_packet_encoder.byte_index\[0\] u_parser.u_packet_encoder.byte_index\[1\]
+ VGND VGND VPWR VPWR _0895_ sky130_fd_sc_hd__or2_4
X_3604_ clknet_leaf_9_clk _0431_ net115 VGND VGND VPWR VPWR u_parser.u_decoder.ascii_buf\[8\]\[7\]
+ sky130_fd_sc_hd__dfrtp_1
X_1796_ _0850_ _0851_ VGND VGND VPWR VPWR _0852_ sky130_fd_sc_hd__or2_2
X_3535_ clknet_leaf_46_clk _0362_ net104 VGND VGND VPWR VPWR u_parser.u_decoder.decoded_payload\[18\]
+ sky130_fd_sc_hd__dfrtp_1
X_3466_ clknet_leaf_57_clk _0293_ net95 VGND VGND VPWR VPWR tag_raw\[20\] sky130_fd_sc_hd__dfrtp_1
X_2417_ net460 _1153_ _1157_ VGND VGND VPWR VPWR _0326_ sky130_fd_sc_hd__a21oi_1
X_3397_ clknet_leaf_42_clk _0230_ net108 VGND VGND VPWR VPWR u_parser.u_packet_encoder.tag_latched\[33\]
+ sky130_fd_sc_hd__dfrtp_1
XFILLER_57_503 VGND VGND VPWR VPWR sky130_fd_sc_hd__fill_1
X_2348_ tag_raw\[1\] net449 net17 VGND VGND VPWR VPWR _0274_ sky130_fd_sc_hd__mux2_1
XFILLER_29_216 VGND VGND VPWR VPWR sky130_fd_sc_hd__decap_8
X_2279_ u_tx_fifo.mem\[8\]\[2\] u_tx_fifo.mem\[9\]\[2\] u_tx_fifo.mem\[10\]\[2\] u_tx_fifo.mem\[11\]\[2\]
+ net66 net62 VGND VGND VPWR VPWR _1087_ sky130_fd_sc_hd__mux4_1
XFILLER_84_388 VGND VGND VPWR VPWR sky130_fd_sc_hd__fill_1
XTAP_TAPCELL_ROW_55_726 VGND VPWR sky130_fd_sc_hd__tapvpwrvgnd_1
XFILLER_52_241 VGND VGND VPWR VPWR sky130_fd_sc_hd__decap_8
XFILLER_16_79 VGND VGND VPWR VPWR sky130_fd_sc_hd__decap_4
XFILLER_12_127 VGND VGND VPWR VPWR sky130_fd_sc_hd__decap_4
XFILLER_12_149 VGND VGND VPWR VPWR sky130_fd_sc_hd__fill_1
XFILLER_32_67 VGND VGND VPWR VPWR sky130_fd_sc_hd__fill_1
XFILLER_75_366 VPWR VGND VPWR VGND sky130_ef_sc_hd__decap_12
XFILLER_71_550 VGND VGND VPWR VPWR sky130_fd_sc_hd__decap_4
XTAP_TAPCELL_ROW_26_450 VGND VPWR sky130_fd_sc_hd__tapvpwrvgnd_1
XFILLER_43_285 VGND VGND VPWR VPWR sky130_fd_sc_hd__fill_1
X_1650_ _0715_ _0716_ net146 VGND VGND VPWR VPWR _0717_ sky130_fd_sc_hd__mux2_1
Xhold109 u_rx_fifo.mem\[8\]\[5\] VGND VGND VPWR VPWR net265 sky130_fd_sc_hd__dlygate4sd3_1
X_3320_ clknet_leaf_17_clk _0156_ VGND VGND VPWR VPWR u_rx_fifo.mem\[4\]\[7\] sky130_fd_sc_hd__dfxtp_1
X_3251_ clknet_leaf_3_clk _0087_ VGND VGND VPWR VPWR u_tx_fifo.mem\[6\]\[2\] sky130_fd_sc_hd__dfxtp_1
XFILLER_21_3 VGND VGND VPWR VPWR sky130_fd_sc_hd__decap_6
X_2202_ tag_raw\[9\] net511 net55 VGND VGND VPWR VPWR _0206_ sky130_fd_sc_hd__mux2_1
X_3182_ clknet_leaf_16_clk _0018_ net120 VGND VGND VPWR VPWR u_rx_fifo.wr_ptr\[2\]
+ sky130_fd_sc_hd__dfrtp_4
X_2133_ _0997_ _1010_ VGND VGND VPWR VPWR _1011_ sky130_fd_sc_hd__xnor2_2
XFILLER_93_141 VGND VGND VPWR VPWR sky130_fd_sc_hd__fill_1
X_2064_ net162 net21 _0960_ VGND VGND VPWR VPWR _0170_ sky130_fd_sc_hd__mux2_1
XTAP_TAPCELL_ROW_60_773 VGND VPWR sky130_fd_sc_hd__tapvpwrvgnd_1
X_2966_ net87 _1487_ VGND VGND VPWR VPWR _1488_ sky130_fd_sc_hd__nor2_1
X_2897_ net640 _1442_ net6 VGND VGND VPWR VPWR _1445_ sky130_fd_sc_hd__o21ai_1
X_1917_ _0929_ _0937_ _0939_ _0904_ u_parser.u_packet_encoder.crc_latched\[7\] VGND
+ VGND VPWR VPWR _0940_ sky130_fd_sc_hd__o32a_1
XFILLER_8_91 VGND VGND VPWR VPWR sky130_fd_sc_hd__fill_2
XFILLER_8_80 VGND VGND VPWR VPWR sky130_fd_sc_hd__decap_4
X_1848_ u_rx_fifo.wr_ptr\[0\] u_rx_fifo.wr_ptr\[1\] _0849_ VGND VGND VPWR VPWR _0886_
+ sky130_fd_sc_hd__or3_4
X_1779_ u_uart_rx.low_count\[1\] u_uart_rx.low_count\[2\] u_uart_rx.low_count\[4\]
+ u_uart_rx.low_count\[3\] VGND VGND VPWR VPWR _0839_ sky130_fd_sc_hd__o211a_1
X_3518_ clknet_leaf_46_clk _0345_ net104 VGND VGND VPWR VPWR u_parser.u_decoder.decoded_payload\[1\]
+ sky130_fd_sc_hd__dfrtp_1
XFILLER_89_469 VPWR VGND VPWR VGND sky130_ef_sc_hd__decap_12
X_3449_ clknet_leaf_46_clk net469 net104 VGND VGND VPWR VPWR tag_raw\[3\] sky130_fd_sc_hd__dfrtp_1
XFILLER_84_141 VGND VGND VPWR VPWR sky130_fd_sc_hd__decap_3
XTAP_TAPCELL_ROW_68_851 VGND VPWR sky130_fd_sc_hd__tapvpwrvgnd_1
XFILLER_13_425 VGND VGND VPWR VPWR sky130_fd_sc_hd__fill_2
XFILLER_13_447 VGND VGND VPWR VPWR sky130_fd_sc_hd__fill_1
XTAP_TAPCELL_ROW_23_420 VGND VPWR sky130_fd_sc_hd__tapvpwrvgnd_1
XFILLER_40_233 VGND VGND VPWR VPWR sky130_fd_sc_hd__fill_1
XFILLER_43_55 VGND VGND VPWR VPWR sky130_fd_sc_hd__fill_1
XFILLER_13_469 VPWR VGND VPWR VGND sky130_ef_sc_hd__decap_12
XFILLER_9_429 VPWR VGND VPWR VGND sky130_ef_sc_hd__decap_12
XFILLER_4_27 VGND VGND VPWR VPWR sky130_fd_sc_hd__fill_1
XFILLER_68_41 VGND VGND VPWR VPWR sky130_fd_sc_hd__decap_8
XFILLER_48_377 VGND VGND VPWR VPWR sky130_fd_sc_hd__decap_6
XFILLER_31_211 VGND VGND VPWR VPWR sky130_fd_sc_hd__decap_4
X_2820_ net639 net36 _1412_ VGND VGND VPWR VPWR _0474_ sky130_fd_sc_hd__mux2_1
X_2751_ net588 _1385_ net13 VGND VGND VPWR VPWR _0432_ sky130_fd_sc_hd__mux2_1
X_2682_ _1276_ _1335_ VGND VGND VPWR VPWR _1360_ sky130_fd_sc_hd__xnor2_1
X_1702_ net40 net38 net36 VGND VGND VPWR VPWR _0769_ sky130_fd_sc_hd__and3_1
X_1633_ u_uart_rx.state\[2\] _0698_ _0701_ _0702_ VGND VGND VPWR VPWR _0005_ sky130_fd_sc_hd__a22o_1
XFILLER_69_3 VPWR VGND VPWR VGND sky130_ef_sc_hd__decap_12
X_3303_ clknet_leaf_2_clk _0139_ VGND VGND VPWR VPWR u_tx_fifo.mem\[14\]\[6\] sky130_fd_sc_hd__dfxtp_1
X_3234_ clknet_leaf_15_clk _0070_ VGND VGND VPWR VPWR u_rx_fifo.mem\[5\]\[1\] sky130_fd_sc_hd__dfxtp_1
X_3165_ net167 net30 _1585_ VGND VGND VPWR VPWR _0646_ sky130_fd_sc_hd__mux2_1
XFILLER_39_377 VPWR VGND VPWR VGND sky130_ef_sc_hd__decap_12
X_3096_ u_uart_rx.sample_div_count\[13\] _1546_ net635 VGND VGND VPWR VPWR _1551_
+ sky130_fd_sc_hd__a21oi_1
XFILLER_81_111 VGND VGND VPWR VPWR sky130_fd_sc_hd__fill_1
X_2116_ _0985_ _0993_ VGND VGND VPWR VPWR _0994_ sky130_fd_sc_hd__xnor2_2
XFILLER_54_325 VPWR VGND VPWR VGND sky130_ef_sc_hd__decap_12
XTAP_TAPCELL_ROW_65_821 VGND VPWR sky130_fd_sc_hd__tapvpwrvgnd_1
X_2047_ net257 net72 _0958_ VGND VGND VPWR VPWR _0155_ sky130_fd_sc_hd__mux2_1
XTAP_TAPCELL_ROW_37_556 VGND VPWR sky130_fd_sc_hd__tapvpwrvgnd_1
XFILLER_81_177 VGND VGND VPWR VPWR sky130_fd_sc_hd__decap_8
Xfanout26 _0913_ VGND VGND VPWR VPWR net26 sky130_fd_sc_hd__buf_1
Xfanout15 net16 VGND VGND VPWR VPWR net15 sky130_fd_sc_hd__clkbuf_4
Xfanout37 _0768_ VGND VGND VPWR VPWR net37 sky130_fd_sc_hd__clkbuf_2
Xfanout59 u_uart_rx.vote_ones\[1\] VGND VGND VPWR VPWR net59 sky130_fd_sc_hd__buf_2
XFILLER_22_244 VGND VGND VPWR VPWR sky130_fd_sc_hd__decap_8
XFILLER_50_553 VGND VGND VPWR VPWR sky130_fd_sc_hd__fill_2
X_2949_ net617 _1475_ _1477_ VGND VGND VPWR VPWR _0538_ sky130_fd_sc_hd__o21a_1
Xhold451 u_parser.u_decoder.ascii_buf\[8\]\[5\] VGND VGND VPWR VPWR net607 sky130_fd_sc_hd__dlygate4sd3_1
Xhold440 u_parser.u_decoder.decoded_checksum_calc\[7\] VGND VGND VPWR VPWR net596
+ sky130_fd_sc_hd__dlygate4sd3_1
Xhold462 u_parser.u_decoder.timeout_count\[11\] VGND VGND VPWR VPWR net618 sky130_fd_sc_hd__dlygate4sd3_1
Xhold473 u_uart_tx.clk_count\[10\] VGND VGND VPWR VPWR net629 sky130_fd_sc_hd__dlygate4sd3_1
Xhold484 u_uart_tx.clk_count\[2\] VGND VGND VPWR VPWR net640 sky130_fd_sc_hd__dlygate4sd3_1
Xhold495 u_uart_tx.clk_count\[4\] VGND VGND VPWR VPWR net651 sky130_fd_sc_hd__dlygate4sd3_1
XTAP_TAPCELL_ROW_0_192 VGND VPWR sky130_fd_sc_hd__tapvpwrvgnd_1
XFILLER_53_380 VPWR VGND VPWR VGND sky130_ef_sc_hd__decap_12
XTAP_TAPCELL_ROW_71_879 VGND VPWR sky130_fd_sc_hd__tapvpwrvgnd_1
XFILLER_70_53 VGND VGND VPWR VPWR sky130_fd_sc_hd__fill_2
Xclkload29 clknet_leaf_52_clk VGND VGND VPWR VPWR clkload29/Y sky130_fd_sc_hd__inv_6
Xclkload18 clknet_leaf_4_clk VGND VGND VPWR VPWR clkload18/Y sky130_fd_sc_hd__inv_8
XTAP_TAPCELL_ROW_8_281 VGND VPWR sky130_fd_sc_hd__tapvpwrvgnd_1
XFILLER_0_181 VPWR VGND VPWR VGND sky130_ef_sc_hd__decap_12
XFILLER_63_111 VGND VGND VPWR VPWR sky130_fd_sc_hd__fill_1
XTAP_TAPCELL_ROW_34_526 VGND VPWR sky130_fd_sc_hd__tapvpwrvgnd_1
XFILLER_32_553 VGND VGND VPWR VPWR sky130_fd_sc_hd__fill_2
X_2803_ u_parser.u_decoder.ascii_buf\[2\]\[3\] net44 _1410_ VGND VGND VPWR VPWR _0459_
+ sky130_fd_sc_hd__mux2_1
X_3783_ clknet_leaf_27_clk _0601_ net138 VGND VGND VPWR VPWR u_uart_rx.sample_div_count\[3\]
+ sky130_fd_sc_hd__dfrtp_1
X_2734_ net40 u_parser.u_decoder.ascii_buf\[8\]\[0\] _1376_ VGND VGND VPWR VPWR _0424_
+ sky130_fd_sc_hd__mux2_1
X_2665_ u_parser.u_decoder.decoded_checksum_calc\[1\] _1346_ net13 VGND VGND VPWR
+ VPWR _0385_ sky130_fd_sc_hd__mux2_1
X_2596_ net471 _1292_ net10 VGND VGND VPWR VPWR _0370_ sky130_fd_sc_hd__mux2_1
X_1616_ net603 VGND VGND VPWR VPWR _0686_ sky130_fd_sc_hd__inv_2
X_3217_ clknet_leaf_14_clk _0053_ VGND VGND VPWR VPWR u_rx_fifo.mem\[7\]\[0\] sky130_fd_sc_hd__dfxtp_1
X_3148_ net59 net490 _1580_ VGND VGND VPWR VPWR _0634_ sky130_fd_sc_hd__mux2_1
XFILLER_39_185 VGND VGND VPWR VPWR sky130_fd_sc_hd__fill_1
XFILLER_54_122 VGND VGND VPWR VPWR sky130_fd_sc_hd__fill_2
X_3079_ net642 _1536_ _1539_ VGND VGND VPWR VPWR _0606_ sky130_fd_sc_hd__o21a_1
XFILLER_42_317 VGND VGND VPWR VPWR sky130_fd_sc_hd__fill_2
XFILLER_42_339 VGND VGND VPWR VPWR sky130_fd_sc_hd__decap_4
XFILLER_10_247 VGND VGND VPWR VPWR sky130_fd_sc_hd__decap_4
XFILLER_2_413 VGND VGND VPWR VPWR sky130_fd_sc_hd__decap_6
XFILLER_2_457 VPWR VGND VPWR VGND sky130_ef_sc_hd__decap_12
Xhold270 u_parser.u_decoder.decoded_payload\[12\] VGND VGND VPWR VPWR net426 sky130_fd_sc_hd__dlygate4sd3_1
Xhold292 u_uart_tx.tx_data\[4\] VGND VGND VPWR VPWR net448 sky130_fd_sc_hd__dlygate4sd3_1
Xhold281 tag_raw\[17\] VGND VGND VPWR VPWR net437 sky130_fd_sc_hd__dlygate4sd3_1
XTAP_TAPCELL_ROW_5_251 VGND VPWR sky130_fd_sc_hd__tapvpwrvgnd_1
XTAP_TAPCELL_ROW_76_927 VGND VPWR sky130_fd_sc_hd__tapvpwrvgnd_1
XFILLER_1_39 VGND VGND VPWR VPWR sky130_fd_sc_hd__decap_8
XFILLER_45_111 VGND VGND VPWR VPWR sky130_fd_sc_hd__fill_1
XFILLER_58_472 VGND VGND VPWR VPWR sky130_fd_sc_hd__decap_4
XTAP_TAPCELL_ROW_86_1023 VGND VPWR sky130_fd_sc_hd__tapvpwrvgnd_1
XFILLER_85_291 VGND VGND VPWR VPWR sky130_fd_sc_hd__decap_6
XFILLER_14_553 VGND VGND VPWR VPWR sky130_fd_sc_hd__fill_2
XFILLER_60_169 VGND VGND VPWR VPWR sky130_fd_sc_hd__fill_1
XFILLER_41_361 VGND VGND VPWR VPWR sky130_fd_sc_hd__fill_1
X_2450_ u_parser.u_decoder.timeout_count\[12\] u_parser.u_decoder.timeout_count\[13\]
+ u_parser.u_decoder.timeout_count\[11\] u_parser.u_decoder.timeout_count\[9\] VGND
+ VGND VPWR VPWR _1179_ sky130_fd_sc_hd__and4_1
XFILLER_5_295 VGND VGND VPWR VPWR sky130_fd_sc_hd__fill_1
X_2381_ tag_raw\[34\] net496 net18 VGND VGND VPWR VPWR _0307_ sky130_fd_sc_hd__mux2_1
XFILLER_83_206 VPWR VGND VPWR VGND sky130_ef_sc_hd__decap_12
X_3002_ net168 net34 _1504_ VGND VGND VPWR VPWR _0564_ sky130_fd_sc_hd__mux2_1
XTAP_TAPCELL_ROW_47_651 VGND VPWR sky130_fd_sc_hd__tapvpwrvgnd_1
XFILLER_64_475 VGND VGND VPWR VPWR sky130_fd_sc_hd__fill_1
XTAP_TAPCELL_ROW_19_386 VGND VPWR sky130_fd_sc_hd__tapvpwrvgnd_1
XFILLER_51_125 VPWR VGND VPWR VGND sky130_ef_sc_hd__decap_12
XFILLER_64_497 VGND VGND VPWR VPWR sky130_fd_sc_hd__fill_1
X_3835_ clknet_leaf_63_clk _0651_ VGND VGND VPWR VPWR u_tx_fifo.mem\[11\]\[4\] sky130_fd_sc_hd__dfxtp_1
XFILLER_20_545 VGND VGND VPWR VPWR sky130_fd_sc_hd__decap_8
X_3766_ clknet_leaf_10_clk _0584_ VGND VGND VPWR VPWR u_rx_fifo.mem\[9\]\[7\] sky130_fd_sc_hd__dfxtp_1
X_2717_ u_parser.u_decoder.ascii_buf\[7\]\[1\] net39 _1374_ VGND VGND VPWR VPWR _0409_
+ sky130_fd_sc_hd__mux2_1
XFILLER_10_15 VGND VGND VPWR VPWR sky130_fd_sc_hd__decap_4
X_3697_ clknet_leaf_50_clk _0521_ net92 VGND VGND VPWR VPWR u_uart_tx.clk_count\[4\]
+ sky130_fd_sc_hd__dfrtp_1
X_2648_ u_parser.u_decoder.ascii_buf\[0\]\[1\] _1328_ VGND VGND VPWR VPWR _1334_ sky130_fd_sc_hd__xnor2_1
X_2579_ u_parser.u_decoder.ascii_buf\[4\]\[3\] _1267_ _1272_ VGND VGND VPWR VPWR _1279_
+ sky130_fd_sc_hd__a21o_1
XFILLER_59_258 VGND VGND VPWR VPWR sky130_fd_sc_hd__decap_4
XTAP_TAPCELL_ROW_2_221 VGND VPWR sky130_fd_sc_hd__tapvpwrvgnd_1
XFILLER_19_57 VGND VGND VPWR VPWR sky130_fd_sc_hd__decap_3
XFILLER_70_412 VGND VGND VPWR VPWR sky130_fd_sc_hd__decap_8
XFILLER_70_445 VGND VGND VPWR VPWR sky130_fd_sc_hd__decap_8
XTAP_TAPCELL_ROW_81_974 VGND VPWR sky130_fd_sc_hd__tapvpwrvgnd_1
XFILLER_7_505 VPWR VGND VPWR VGND sky130_ef_sc_hd__decap_12
XFILLER_51_55 VGND VGND VPWR VPWR sky130_fd_sc_hd__fill_1
XTAP_TAPCELL_ROW_92_1071 VGND VPWR sky130_fd_sc_hd__tapvpwrvgnd_1
XFILLER_76_41 VGND VGND VPWR VPWR sky130_fd_sc_hd__decap_6
XFILLER_65_206 VGND VGND VPWR VPWR sky130_fd_sc_hd__fill_1
XFILLER_46_453 VPWR VGND VPWR VGND sky130_ef_sc_hd__decap_12
XFILLER_61_401 VGND VGND VPWR VPWR sky130_fd_sc_hd__fill_1
XTAP_TAPCELL_ROW_44_621 VGND VPWR sky130_fd_sc_hd__tapvpwrvgnd_1
XFILLER_46_497 VGND VGND VPWR VPWR sky130_fd_sc_hd__decap_4
XTAP_TAPCELL_ROW_16_356 VGND VPWR sky130_fd_sc_hd__tapvpwrvgnd_1
X_1950_ net79 net381 _0944_ VGND VGND VPWR VPWR _0072_ sky130_fd_sc_hd__mux2_1
X_1881_ u_parser.u_packet_encoder.tag_latched\[25\] _0900_ _0909_ VGND VGND VPWR VPWR
+ _0910_ sky130_fd_sc_hd__a21o_1
X_3620_ clknet_leaf_23_clk _0447_ net117 VGND VGND VPWR VPWR u_parser.u_decoder.ascii_buf\[0\]\[7\]
+ sky130_fd_sc_hd__dfrtp_1
X_3551_ clknet_leaf_43_clk _0378_ net107 VGND VGND VPWR VPWR u_parser.u_decoder.decoded_payload\[34\]
+ sky130_fd_sc_hd__dfrtp_1
X_2502_ u_parser.u_decoder.ascii_buf\[8\]\[0\] u_parser.u_decoder.ascii_buf\[8\]\[1\]
+ _1210_ u_parser.u_decoder.ascii_buf\[8\]\[2\] VGND VGND VPWR VPWR _1219_ sky130_fd_sc_hd__a31o_1
X_3482_ clknet_leaf_56_clk _0309_ net99 VGND VGND VPWR VPWR tag_raw\[36\] sky130_fd_sc_hd__dfrtp_4
XFILLER_51_3 VPWR VGND VPWR VGND sky130_ef_sc_hd__decap_12
X_2433_ u_parser.u_decoder.timeout_count\[7\] u_parser.u_decoder.timeout_count\[6\]
+ _1165_ VGND VGND VPWR VPWR _1168_ sky130_fd_sc_hd__and3_1
XFILLER_69_501 VGND VGND VPWR VPWR sky130_fd_sc_hd__decap_3
X_2364_ net437 net430 net18 VGND VGND VPWR VPWR _0290_ sky130_fd_sc_hd__mux2_1
X_2295_ u_tx_fifo.mem\[4\]\[4\] u_tx_fifo.mem\[5\]\[4\] u_tx_fifo.mem\[6\]\[4\] u_tx_fifo.mem\[7\]\[4\]
+ net69 net65 VGND VGND VPWR VPWR _1101_ sky130_fd_sc_hd__mux4_1
X_3818_ clknet_leaf_17_clk _0634_ net121 VGND VGND VPWR VPWR u_uart_rx.rx_shift\[3\]
+ sky130_fd_sc_hd__dfrtp_1
XTAP_TAPCELL_ROW_50_679 VGND VPWR sky130_fd_sc_hd__tapvpwrvgnd_1
X_3749_ clknet_leaf_34_clk net161 net134 VGND VGND VPWR VPWR rdm_rx_sync sky130_fd_sc_hd__dfstp_2
XFILLER_75_537 VPWR VGND VPWR VGND sky130_ef_sc_hd__decap_12
XTAP_TAPCELL_ROW_58_757 VGND VPWR sky130_fd_sc_hd__tapvpwrvgnd_1
XFILLER_46_77 VGND VGND VPWR VPWR sky130_fd_sc_hd__decap_6
Xmax_cap45 _1326_ VGND VGND VPWR VPWR net45 sky130_fd_sc_hd__clkbuf_1
XFILLER_28_486 VGND VGND VPWR VPWR sky130_fd_sc_hd__decap_8
XFILLER_43_445 VGND VGND VPWR VPWR sky130_fd_sc_hd__decap_3
XTAP_TAPCELL_ROW_13_326 VGND VPWR sky130_fd_sc_hd__tapvpwrvgnd_1
XFILLER_30_139 VGND VGND VPWR VPWR sky130_fd_sc_hd__fill_1
XFILLER_7_27 VGND VGND VPWR VPWR sky130_fd_sc_hd__decap_4
XFILLER_3_541 VPWR VGND VPWR VGND sky130_ef_sc_hd__decap_12
XFILLER_78_353 VGND VGND VPWR VPWR sky130_fd_sc_hd__decap_3
X_2080_ _0965_ u_parser.u_decoder.index\[2\] u_parser.u_decoder.index\[3\] VGND VGND
+ VPWR VPWR _0966_ sky130_fd_sc_hd__nor3b_2
XFILLER_93_389 VGND VGND VPWR VPWR sky130_fd_sc_hd__decap_3
XTAP_TAPCELL_ROW_29_481 VGND VPWR sky130_fd_sc_hd__tapvpwrvgnd_1
XFILLER_46_272 VGND VGND VPWR VPWR sky130_fd_sc_hd__decap_8
X_2982_ net87 _1498_ VGND VGND VPWR VPWR _0550_ sky130_fd_sc_hd__nor2_1
XFILLER_34_489 VGND VGND VPWR VPWR sky130_fd_sc_hd__decap_6
X_1933_ net75 net391 _0874_ VGND VGND VPWR VPWR _0058_ sky130_fd_sc_hd__mux2_1
X_1864_ u_parser.u_packet_encoder.byte_index\[3\] u_parser.u_packet_encoder.byte_index\[2\]
+ u_parser.u_packet_encoder.byte_index\[0\] u_parser.u_packet_encoder.byte_index\[1\]
+ VGND VGND VPWR VPWR _0894_ sky130_fd_sc_hd__and4b_4
X_3603_ clknet_leaf_9_clk _0430_ net115 VGND VGND VPWR VPWR u_parser.u_decoder.ascii_buf\[8\]\[6\]
+ sky130_fd_sc_hd__dfrtp_1
X_1795_ _0797_ _0849_ VGND VGND VPWR VPWR _0851_ sky130_fd_sc_hd__nor2_1
X_3534_ clknet_leaf_45_clk _0361_ net109 VGND VGND VPWR VPWR u_parser.u_decoder.decoded_payload\[17\]
+ sky130_fd_sc_hd__dfrtp_1
X_3465_ clknet_leaf_45_clk _0292_ net109 VGND VGND VPWR VPWR tag_raw\[19\] sky130_fd_sc_hd__dfrtp_1
X_2416_ u_parser.u_decoder.timeout_count\[1\] _1153_ net3 VGND VGND VPWR VPWR _1157_
+ sky130_fd_sc_hd__o21ai_1
X_3396_ clknet_leaf_42_clk _0229_ net108 VGND VGND VPWR VPWR u_parser.u_packet_encoder.tag_latched\[32\]
+ sky130_fd_sc_hd__dfrtp_1
X_2347_ tag_raw\[0\] net436 net17 VGND VGND VPWR VPWR _0273_ sky130_fd_sc_hd__mux2_1
X_2278_ _1084_ _1085_ net61 VGND VGND VPWR VPWR _1086_ sky130_fd_sc_hd__mux2_1
XFILLER_84_356 VGND VGND VPWR VPWR sky130_fd_sc_hd__decap_8
XFILLER_25_434 VPWR VGND VPWR VGND sky130_ef_sc_hd__decap_12
XTAP_TAPCELL_ROW_55_727 VGND VPWR sky130_fd_sc_hd__tapvpwrvgnd_1
XFILLER_40_404 VPWR VGND VPWR VGND sky130_ef_sc_hd__decap_12
XFILLER_40_426 VGND VGND VPWR VPWR sky130_fd_sc_hd__decap_8
XFILLER_79_117 VGND VGND VPWR VPWR sky130_fd_sc_hd__fill_1
XFILLER_0_533 VPWR VGND VPWR VGND sky130_ef_sc_hd__decap_12
XFILLER_28_250 VGND VGND VPWR VPWR sky130_fd_sc_hd__fill_2
XFILLER_63_529 VPWR VGND VPWR VGND sky130_ef_sc_hd__decap_12
XFILLER_75_378 VPWR VGND VPWR VGND sky130_ef_sc_hd__decap_12
XTAP_TAPCELL_ROW_26_451 VGND VPWR sky130_fd_sc_hd__tapvpwrvgnd_1
XFILLER_43_264 VGND VGND VPWR VPWR sky130_fd_sc_hd__decap_8
XFILLER_3_360 VPWR VGND VPWR VGND sky130_ef_sc_hd__decap_12
XFILLER_3_393 VPWR VGND VPWR VGND sky130_ef_sc_hd__decap_12
X_3250_ clknet_leaf_3_clk _0086_ VGND VGND VPWR VPWR u_tx_fifo.mem\[6\]\[1\] sky130_fd_sc_hd__dfxtp_1
X_2201_ tag_raw\[8\] net508 net56 VGND VGND VPWR VPWR _0205_ sky130_fd_sc_hd__mux2_1
XFILLER_39_526 VGND VGND VPWR VPWR sky130_fd_sc_hd__decap_3
XFILLER_66_301 VGND VGND VPWR VPWR sky130_fd_sc_hd__decap_6
X_3181_ clknet_leaf_20_clk _0017_ net120 VGND VGND VPWR VPWR u_rx_fifo.wr_ptr\[1\]
+ sky130_fd_sc_hd__dfrtp_1
XFILLER_78_194 VGND VGND VPWR VPWR sky130_fd_sc_hd__fill_2
XFILLER_14_3 VGND VGND VPWR VPWR sky130_fd_sc_hd__decap_6
X_2132_ _1003_ _1009_ VGND VGND VPWR VPWR _1010_ sky130_fd_sc_hd__xnor2_2
XFILLER_93_197 VPWR VGND VPWR VGND sky130_ef_sc_hd__decap_12
X_2063_ net204 net32 _0960_ VGND VGND VPWR VPWR _0169_ sky130_fd_sc_hd__mux2_1
XFILLER_81_359 VPWR VGND VPWR VGND sky130_ef_sc_hd__decap_12
X_2965_ u_uart_rx.low_count\[11\] _1486_ VGND VGND VPWR VPWR _1487_ sky130_fd_sc_hd__and2_1
XTAP_TAPCELL_ROW_60_774 VGND VPWR sky130_fd_sc_hd__tapvpwrvgnd_1
X_2896_ u_uart_tx.clk_count\[2\] u_uart_tx.clk_count\[1\] _1439_ VGND VGND VPWR VPWR
+ _1444_ sky130_fd_sc_hd__and3_1
X_1916_ u_parser.u_packet_encoder.tag_latched\[39\] _0896_ _0900_ u_parser.u_packet_encoder.tag_latched\[31\]
+ _0938_ VGND VGND VPWR VPWR _0939_ sky130_fd_sc_hd__a221o_1
X_1847_ net415 net70 _0885_ VGND VGND VPWR VPWR _0028_ sky130_fd_sc_hd__mux2_1
X_3517_ clknet_leaf_48_clk _0344_ net104 VGND VGND VPWR VPWR u_parser.u_decoder.decoded_payload\[0\]
+ sky130_fd_sc_hd__dfrtp_1
X_1778_ u_uart_rx.low_count\[12\] u_uart_rx.low_count\[11\] _0837_ VGND VGND VPWR
+ VPWR _0838_ sky130_fd_sc_hd__and3_1
XFILLER_89_426 VGND VGND VPWR VPWR sky130_fd_sc_hd__fill_2
XFILLER_89_415 VGND VGND VPWR VPWR sky130_fd_sc_hd__fill_2
X_3448_ clknet_leaf_46_clk _0275_ net105 VGND VGND VPWR VPWR tag_raw\[2\] sky130_fd_sc_hd__dfrtp_1
X_3379_ clknet_leaf_54_clk _0212_ net98 VGND VGND VPWR VPWR u_parser.u_packet_encoder.tag_latched\[15\]
+ sky130_fd_sc_hd__dfrtp_1
XFILLER_57_334 VGND VGND VPWR VPWR sky130_fd_sc_hd__fill_2
XFILLER_57_345 VGND VGND VPWR VPWR sky130_fd_sc_hd__fill_1
XTAP_TAPCELL_ROW_68_852 VGND VPWR sky130_fd_sc_hd__tapvpwrvgnd_1
XFILLER_80_370 VGND VGND VPWR VPWR sky130_fd_sc_hd__fill_1
XTAP_TAPCELL_ROW_23_421 VGND VPWR sky130_fd_sc_hd__tapvpwrvgnd_1
XFILLER_43_89 VGND VGND VPWR VPWR sky130_fd_sc_hd__fill_2
XFILLER_4_124 VGND VGND VPWR VPWR sky130_fd_sc_hd__fill_2
XFILLER_4_135 VGND VGND VPWR VPWR sky130_fd_sc_hd__decap_4
XFILLER_67_109 VGND VGND VPWR VPWR sky130_fd_sc_hd__decap_3
XTAP_TAPCELL_ROW_89_1043 VGND VPWR sky130_fd_sc_hd__tapvpwrvgnd_1
XFILLER_84_41 VGND VGND VPWR VPWR sky130_fd_sc_hd__decap_6
XFILLER_36_529 VGND VGND VPWR VPWR sky130_fd_sc_hd__decap_3
XFILLER_75_164 VGND VGND VPWR VPWR sky130_fd_sc_hd__decap_4
XFILLER_17_90 VGND VGND VPWR VPWR sky130_fd_sc_hd__fill_2
XFILLER_16_253 VPWR VGND VPWR VGND sky130_ef_sc_hd__decap_12
XFILLER_31_245 VGND VGND VPWR VPWR sky130_fd_sc_hd__decap_4
XFILLER_31_278 VGND VGND VPWR VPWR sky130_fd_sc_hd__fill_2
X_2750_ u_parser.u_decoder.ascii_buf\[11\]\[0\] _1379_ _1384_ VGND VGND VPWR VPWR
+ _1385_ sky130_fd_sc_hd__o21ba_1
X_2681_ _1218_ _1248_ VGND VGND VPWR VPWR _1359_ sky130_fd_sc_hd__xnor2_1
X_1701_ _0763_ _0764_ _0767_ _0671_ VGND VGND VPWR VPWR _0768_ sky130_fd_sc_hd__a22o_1
X_1632_ u_uart_rx.break_detect _0689_ _0695_ VGND VGND VPWR VPWR _0702_ sky130_fd_sc_hd__nor3_1
X_3302_ clknet_leaf_65_clk _0138_ VGND VGND VPWR VPWR u_tx_fifo.mem\[14\]\[5\] sky130_fd_sc_hd__dfxtp_1
X_3233_ clknet_leaf_14_clk _0069_ VGND VGND VPWR VPWR u_rx_fifo.mem\[5\]\[0\] sky130_fd_sc_hd__dfxtp_1
XFILLER_39_334 VGND VGND VPWR VPWR sky130_fd_sc_hd__fill_2
X_3164_ net243 net20 _1585_ VGND VGND VPWR VPWR _0645_ sky130_fd_sc_hd__mux2_1
XFILLER_39_367 VGND VGND VPWR VPWR sky130_fd_sc_hd__fill_1
X_3095_ u_uart_rx.sample_div_count\[13\] u_uart_rx.sample_div_count\[14\] _1546_ _1525_
+ VGND VGND VPWR VPWR _1550_ sky130_fd_sc_hd__a31o_1
X_2115_ tag_raw\[19\] _0992_ VGND VGND VPWR VPWR _0993_ sky130_fd_sc_hd__xor2_1
XFILLER_39_389 VGND VGND VPWR VPWR sky130_fd_sc_hd__decap_3
XFILLER_54_337 VPWR VGND VPWR VGND sky130_ef_sc_hd__decap_12
XTAP_TAPCELL_ROW_65_822 VGND VPWR sky130_fd_sc_hd__tapvpwrvgnd_1
X_2046_ net227 net75 _0958_ VGND VGND VPWR VPWR _0154_ sky130_fd_sc_hd__mux2_1
XTAP_TAPCELL_ROW_37_557 VGND VPWR sky130_fd_sc_hd__tapvpwrvgnd_1
XFILLER_66_197 VPWR VGND VPWR VGND sky130_ef_sc_hd__decap_12
Xfanout27 _0908_ VGND VGND VPWR VPWR net27 sky130_fd_sc_hd__clkbuf_2
Xfanout16 _1140_ VGND VGND VPWR VPWR net16 sky130_fd_sc_hd__clkbuf_4
Xfanout38 _0760_ VGND VGND VPWR VPWR net38 sky130_fd_sc_hd__clkbuf_4
Xfanout49 _0834_ VGND VGND VPWR VPWR net49 sky130_fd_sc_hd__buf_2
X_2948_ net86 _1476_ VGND VGND VPWR VPWR _1477_ sky130_fd_sc_hd__nor2_1
XFILLER_13_37 VGND VGND VPWR VPWR sky130_fd_sc_hd__decap_3
X_2879_ net166 net30 _1437_ VGND VGND VPWR VPWR _0508_ sky130_fd_sc_hd__mux2_1
XFILLER_89_212 VPWR VGND VPWR VGND sky130_ef_sc_hd__decap_12
XFILLER_1_105 VGND VGND VPWR VPWR sky130_fd_sc_hd__decap_6
Xhold463 u_parser.u_decoder.ascii_buf\[8\]\[7\] VGND VGND VPWR VPWR net619 sky130_fd_sc_hd__dlygate4sd3_1
Xhold452 u_parser.u_decoder.ascii_buf\[9\]\[4\] VGND VGND VPWR VPWR net608 sky130_fd_sc_hd__dlygate4sd3_1
Xhold441 u_parser.u_decoder.ascii_buf\[0\]\[4\] VGND VGND VPWR VPWR net597 sky130_fd_sc_hd__dlygate4sd3_1
Xhold430 u_parser.u_decoder.ascii_buf\[10\]\[4\] VGND VGND VPWR VPWR net586 sky130_fd_sc_hd__dlygate4sd3_1
XFILLER_89_256 VGND VGND VPWR VPWR sky130_fd_sc_hd__fill_1
Xhold496 u_uart_tx.clk_count\[6\] VGND VGND VPWR VPWR net652 sky130_fd_sc_hd__dlygate4sd3_1
Xhold474 u_parser.u_decoder.ascii_buf\[4\]\[6\] VGND VGND VPWR VPWR net630 sky130_fd_sc_hd__dlygate4sd3_1
Xhold485 u_parser.u_decoder.ascii_buf\[8\]\[6\] VGND VGND VPWR VPWR net641 sky130_fd_sc_hd__dlygate4sd3_1
XFILLER_85_462 VGND VGND VPWR VPWR sky130_fd_sc_hd__fill_2
XFILLER_60_307 VGND VGND VPWR VPWR sky130_fd_sc_hd__fill_1
XFILLER_13_223 VGND VGND VPWR VPWR sky130_fd_sc_hd__fill_1
XTAP_TAPCELL_ROW_0_193 VGND VPWR sky130_fd_sc_hd__tapvpwrvgnd_1
XFILLER_41_521 VGND VGND VPWR VPWR sky130_fd_sc_hd__fill_1
Xclkload19 clknet_leaf_5_clk VGND VGND VPWR VPWR clkload19/Y sky130_fd_sc_hd__inv_8
XFILLER_68_418 VGND VGND VPWR VPWR sky130_fd_sc_hd__fill_2
XTAP_TAPCELL_ROW_8_282 VGND VPWR sky130_fd_sc_hd__tapvpwrvgnd_1
XFILLER_0_193 VGND VGND VPWR VPWR sky130_fd_sc_hd__decap_3
XFILLER_48_197 VGND VGND VPWR VPWR sky130_fd_sc_hd__fill_2
XTAP_TAPCELL_ROW_34_527 VGND VPWR sky130_fd_sc_hd__tapvpwrvgnd_1
X_3782_ clknet_leaf_27_clk _0600_ net138 VGND VGND VPWR VPWR u_uart_rx.sample_div_count\[2\]
+ sky130_fd_sc_hd__dfrtp_1
XFILLER_81_3 VPWR VGND VPWR VGND sky130_ef_sc_hd__decap_12
X_2802_ u_parser.u_decoder.ascii_buf\[2\]\[2\] net36 _1410_ VGND VGND VPWR VPWR _0458_
+ sky130_fd_sc_hd__mux2_1
X_2733_ _0813_ _0966_ VGND VGND VPWR VPWR _1376_ sky130_fd_sc_hd__nand2b_4
X_2664_ _1291_ _1345_ VGND VGND VPWR VPWR _1346_ sky130_fd_sc_hd__xnor2_1
X_2595_ u_parser.u_decoder.ascii_buf\[3\]\[2\] _1288_ _1287_ VGND VGND VPWR VPWR _1292_
+ sky130_fd_sc_hd__o21a_1
X_1615_ u_parser.u_decoder.ascii_buf\[2\]\[0\] VGND VGND VPWR VPWR _0685_ sky130_fd_sc_hd__inv_2
X_3216_ clknet_leaf_19_clk _0052_ VGND VGND VPWR VPWR u_rx_fifo.mem\[13\]\[7\] sky130_fd_sc_hd__dfxtp_1
X_3147_ _0699_ _1573_ VGND VGND VPWR VPWR _1580_ sky130_fd_sc_hd__or2_1
XFILLER_82_421 VGND VGND VPWR VPWR sky130_fd_sc_hd__decap_8
XFILLER_27_337 VGND VGND VPWR VPWR sky130_fd_sc_hd__fill_1
X_3078_ _1525_ _1538_ VGND VGND VPWR VPWR _1539_ sky130_fd_sc_hd__nor2_1
X_2029_ net367 net19 _0956_ VGND VGND VPWR VPWR _0139_ sky130_fd_sc_hd__mux2_1
XFILLER_35_381 VGND VGND VPWR VPWR sky130_fd_sc_hd__fill_1
XFILLER_54_189 VGND VGND VPWR VPWR sky130_fd_sc_hd__decap_6
XPHY_EDGE_ROW_59_Left_153 VGND VGND VPWR VPWR sky130_fd_sc_hd__decap_3
XFILLER_10_226 VGND VGND VPWR VPWR sky130_fd_sc_hd__fill_1
Xhold260 u_rx_fifo.mem\[1\]\[1\] VGND VGND VPWR VPWR net416 sky130_fd_sc_hd__dlygate4sd3_1
Xhold271 u_parser.u_decoder.decoded_payload\[23\] VGND VGND VPWR VPWR net427 sky130_fd_sc_hd__dlygate4sd3_1
XPHY_EDGE_ROW_68_Left_162 VGND VGND VPWR VPWR sky130_fd_sc_hd__decap_3
XFILLER_77_204 VGND VGND VPWR VPWR sky130_fd_sc_hd__fill_1
XFILLER_2_469 VGND VGND VPWR VPWR sky130_fd_sc_hd__decap_6
Xhold293 u_parser.u_decoder.decoded_payload\[1\] VGND VGND VPWR VPWR net449 sky130_fd_sc_hd__dlygate4sd3_1
Xhold282 u_parser.u_decoder.decoded_payload\[8\] VGND VGND VPWR VPWR net438 sky130_fd_sc_hd__dlygate4sd3_1
XFILLER_49_55 VGND VGND VPWR VPWR sky130_fd_sc_hd__fill_1
XTAP_TAPCELL_ROW_5_252 VGND VPWR sky130_fd_sc_hd__tapvpwrvgnd_1
XFILLER_92_207 VGND VGND VPWR VPWR sky130_fd_sc_hd__fill_1
XTAP_TAPCELL_ROW_76_928 VGND VPWR sky130_fd_sc_hd__tapvpwrvgnd_1
XFILLER_85_281 VGND VGND VPWR VPWR sky130_fd_sc_hd__decap_4
XPHY_EDGE_ROW_77_Left_171 VGND VGND VPWR VPWR sky130_fd_sc_hd__decap_3
XFILLER_45_189 VGND VGND VPWR VPWR sky130_fd_sc_hd__decap_8
XFILLER_81_53 VGND VGND VPWR VPWR sky130_fd_sc_hd__decap_3
XPHY_EDGE_ROW_86_Left_180 VGND VGND VPWR VPWR sky130_fd_sc_hd__decap_3
XFILLER_5_285 VGND VGND VPWR VPWR sky130_fd_sc_hd__fill_1
X_2380_ tag_raw\[33\] net446 net18 VGND VGND VPWR VPWR _0306_ sky130_fd_sc_hd__mux2_1
XFILLER_83_218 VGND VGND VPWR VPWR sky130_fd_sc_hd__decap_6
X_3001_ net199 net23 _1504_ VGND VGND VPWR VPWR _0563_ sky130_fd_sc_hd__mux2_1
XFILLER_64_421 VGND VGND VPWR VPWR sky130_fd_sc_hd__decap_8
XFILLER_24_318 VGND VGND VPWR VPWR sky130_fd_sc_hd__decap_6
XTAP_TAPCELL_ROW_47_652 VGND VPWR sky130_fd_sc_hd__tapvpwrvgnd_1
XFILLER_17_381 VGND VGND VPWR VPWR sky130_fd_sc_hd__decap_8
XFILLER_51_137 VPWR VGND VPWR VGND sky130_ef_sc_hd__decap_12
X_3834_ clknet_leaf_61_clk _0650_ VGND VGND VPWR VPWR u_tx_fifo.mem\[11\]\[3\] sky130_fd_sc_hd__dfxtp_1
XFILLER_32_362 VGND VGND VPWR VPWR sky130_fd_sc_hd__fill_2
X_3765_ clknet_leaf_10_clk _0583_ VGND VGND VPWR VPWR u_rx_fifo.mem\[9\]\[6\] sky130_fd_sc_hd__dfxtp_1
X_3696_ clknet_leaf_50_clk _0520_ net92 VGND VGND VPWR VPWR u_uart_tx.clk_count\[3\]
+ sky130_fd_sc_hd__dfrtp_1
X_2716_ u_parser.u_decoder.ascii_buf\[7\]\[0\] net41 _1374_ VGND VGND VPWR VPWR _0408_
+ sky130_fd_sc_hd__mux2_1
XFILLER_10_27 VGND VGND VPWR VPWR sky130_fd_sc_hd__fill_1
X_2647_ u_parser.u_decoder.ascii_buf\[0\]\[5\] _1330_ _1331_ _1326_ VGND VGND VPWR
+ VPWR _1333_ sky130_fd_sc_hd__a211o_1
X_2578_ net443 _1278_ net7 VGND VGND VPWR VPWR _0366_ sky130_fd_sc_hd__mux2_1
XFILLER_59_237 VGND VGND VPWR VPWR sky130_fd_sc_hd__fill_1
XTAP_TAPCELL_ROW_2_222 VGND VPWR sky130_fd_sc_hd__tapvpwrvgnd_1
XFILLER_82_251 VGND VGND VPWR VPWR sky130_fd_sc_hd__fill_1
XFILLER_27_145 VGND VGND VPWR VPWR sky130_fd_sc_hd__fill_2
XFILLER_55_465 VGND VGND VPWR VPWR sky130_fd_sc_hd__fill_2
XFILLER_15_329 VGND VGND VPWR VPWR sky130_fd_sc_hd__decap_6
XFILLER_35_57 VGND VGND VPWR VPWR sky130_fd_sc_hd__decap_8
XFILLER_55_487 VPWR VGND VPWR VGND sky130_ef_sc_hd__decap_12
XTAP_TAPCELL_ROW_81_975 VGND VPWR sky130_fd_sc_hd__tapvpwrvgnd_1
XFILLER_42_159 VPWR VGND VPWR VGND sky130_ef_sc_hd__decap_12
XPHY_EDGE_ROW_14_Right_14 VGND VGND VPWR VPWR sky130_fd_sc_hd__decap_3
Xclkbuf_3_3__f_clk clknet_0_clk VGND VGND VPWR VPWR clknet_3_3__leaf_clk sky130_fd_sc_hd__clkbuf_16
XFILLER_7_517 VPWR VGND VPWR VGND sky130_ef_sc_hd__decap_12
XFILLER_2_211 VGND VGND VPWR VPWR sky130_fd_sc_hd__fill_1
XFILLER_2_244 VGND VGND VPWR VPWR sky130_fd_sc_hd__fill_1
XTAP_TAPCELL_ROW_92_1072 VGND VPWR sky130_fd_sc_hd__tapvpwrvgnd_1
XPHY_EDGE_ROW_23_Right_23 VGND VGND VPWR VPWR sky130_fd_sc_hd__decap_3
XFILLER_93_505 VPWR VGND VPWR VGND sky130_ef_sc_hd__decap_12
XFILLER_65_218 VGND VGND VPWR VPWR sky130_fd_sc_hd__decap_6
XFILLER_46_421 VGND VGND VPWR VPWR sky130_fd_sc_hd__decap_8
XFILLER_58_281 VPWR VGND VPWR VGND sky130_ef_sc_hd__decap_12
XFILLER_46_465 VGND VGND VPWR VPWR sky130_fd_sc_hd__decap_8
XFILLER_92_41 VPWR VGND VPWR VGND sky130_ef_sc_hd__decap_12
XTAP_TAPCELL_ROW_44_622 VGND VPWR sky130_fd_sc_hd__tapvpwrvgnd_1
XTAP_TAPCELL_ROW_16_357 VGND VPWR sky130_fd_sc_hd__tapvpwrvgnd_1
XPHY_EDGE_ROW_32_Right_32 VGND VGND VPWR VPWR sky130_fd_sc_hd__decap_3
XFILLER_14_384 VGND VGND VPWR VPWR sky130_fd_sc_hd__decap_4
X_1880_ u_parser.u_packet_encoder.tag_latched\[17\] _0899_ _0902_ u_parser.u_packet_encoder.tag_latched\[1\]
+ VGND VGND VPWR VPWR _0909_ sky130_fd_sc_hd__a22o_1
X_3550_ clknet_leaf_41_clk _0377_ net107 VGND VGND VPWR VPWR u_parser.u_decoder.decoded_payload\[33\]
+ sky130_fd_sc_hd__dfrtp_1
X_2501_ net457 _1218_ net7 VGND VGND VPWR VPWR _0349_ sky130_fd_sc_hd__mux2_1
X_3481_ clknet_leaf_40_clk _0308_ net106 VGND VGND VPWR VPWR tag_raw\[35\] sky130_fd_sc_hd__dfrtp_2
X_2432_ u_parser.u_decoder.timeout_count\[6\] _1152_ _1163_ u_parser.u_decoder.timeout_count\[7\]
+ VGND VGND VPWR VPWR _1167_ sky130_fd_sc_hd__a31o_1
XPHY_EDGE_ROW_41_Right_41 VGND VGND VPWR VPWR sky130_fd_sc_hd__decap_3
XFILLER_44_3 VPWR VGND VPWR VGND sky130_ef_sc_hd__decap_12
X_2363_ net470 net466 net18 VGND VGND VPWR VPWR _0289_ sky130_fd_sc_hd__mux2_1
X_2294_ u_tx_fifo.mem\[0\]\[4\] u_tx_fifo.mem\[1\]\[4\] u_tx_fifo.mem\[2\]\[4\] u_tx_fifo.mem\[3\]\[4\]
+ net69 net65 VGND VGND VPWR VPWR _1100_ sky130_fd_sc_hd__mux4_1
XFILLER_37_443 VGND VGND VPWR VPWR sky130_fd_sc_hd__decap_4
XFILLER_49_281 VGND VGND VPWR VPWR sky130_fd_sc_hd__decap_8
XFILLER_64_251 VGND VGND VPWR VPWR sky130_fd_sc_hd__fill_1
XPHY_EDGE_ROW_50_Right_50 VGND VGND VPWR VPWR sky130_fd_sc_hd__decap_3
XFILLER_32_192 VGND VGND VPWR VPWR sky130_fd_sc_hd__decap_4
X_3817_ clknet_leaf_18_clk _0633_ net123 VGND VGND VPWR VPWR u_uart_rx.rx_shift\[2\]
+ sky130_fd_sc_hd__dfrtp_1
XFILLER_20_365 VGND VGND VPWR VPWR sky130_fd_sc_hd__decap_4
X_3748_ clknet_leaf_4_clk net158 VGND VGND VPWR VPWR rst_n sky130_fd_sc_hd__dfxtp_2
X_3679_ clknet_leaf_64_clk _0506_ VGND VGND VPWR VPWR u_tx_fifo.mem\[10\]\[5\] sky130_fd_sc_hd__dfxtp_1
XFILLER_87_365 VGND VGND VPWR VPWR sky130_fd_sc_hd__decap_3
XFILLER_75_549 VGND VGND VPWR VPWR sky130_fd_sc_hd__decap_6
XFILLER_28_443 VPWR VGND VPWR VGND sky130_ef_sc_hd__decap_12
Xmax_cap46 _1267_ VGND VGND VPWR VPWR net46 sky130_fd_sc_hd__clkbuf_1
XFILLER_43_402 VGND VGND VPWR VPWR sky130_fd_sc_hd__fill_2
XFILLER_70_210 VGND VGND VPWR VPWR sky130_fd_sc_hd__decap_4
XFILLER_70_232 VGND VGND VPWR VPWR sky130_fd_sc_hd__fill_1
XTAP_TAPCELL_ROW_13_327 VGND VPWR sky130_fd_sc_hd__tapvpwrvgnd_1
Xclkbuf_leaf_50_clk clknet_3_2__leaf_clk VGND VGND VPWR VPWR clknet_leaf_50_clk sky130_fd_sc_hd__clkbuf_8
XFILLER_23_181 VGND VGND VPWR VPWR sky130_fd_sc_hd__decap_6
XFILLER_51_490 VGND VGND VPWR VPWR sky130_fd_sc_hd__fill_2
XFILLER_11_92 VGND VGND VPWR VPWR sky130_fd_sc_hd__decap_8
XFILLER_3_553 VGND VGND VPWR VPWR sky130_fd_sc_hd__fill_2
XFILLER_38_207 VGND VGND VPWR VPWR sky130_fd_sc_hd__decap_4
XFILLER_66_527 VGND VGND VPWR VPWR sky130_fd_sc_hd__decap_4
X_2981_ u_uart_rx.low_count\[15\] _1496_ net542 VGND VGND VPWR VPWR _1498_ sky130_fd_sc_hd__a21oi_1
Xclkbuf_leaf_41_clk clknet_3_3__leaf_clk VGND VGND VPWR VPWR clknet_leaf_41_clk sky130_fd_sc_hd__clkbuf_8
X_1932_ net77 net382 _0874_ VGND VGND VPWR VPWR _0057_ sky130_fd_sc_hd__mux2_1
X_1863_ u_parser.u_packet_encoder.byte_index\[3\] u_parser.u_packet_encoder.byte_index\[2\]
+ VGND VGND VPWR VPWR _0893_ sky130_fd_sc_hd__nand2b_2
X_3602_ clknet_leaf_8_clk _0429_ net115 VGND VGND VPWR VPWR u_parser.u_decoder.ascii_buf\[8\]\[5\]
+ sky130_fd_sc_hd__dfrtp_1
X_1794_ _0797_ _0849_ VGND VGND VPWR VPWR _0850_ sky130_fd_sc_hd__and2_1
X_3533_ clknet_leaf_45_clk _0360_ net109 VGND VGND VPWR VPWR u_parser.u_decoder.decoded_payload\[16\]
+ sky130_fd_sc_hd__dfrtp_1
X_3464_ clknet_leaf_46_clk net451 net104 VGND VGND VPWR VPWR tag_raw\[18\] sky130_fd_sc_hd__dfrtp_1
X_2415_ _1152_ _1155_ VGND VGND VPWR VPWR _1156_ sky130_fd_sc_hd__nand2_1
X_3395_ clknet_leaf_54_clk _0228_ net98 VGND VGND VPWR VPWR u_parser.u_packet_encoder.tag_latched\[31\]
+ sky130_fd_sc_hd__dfrtp_1
X_2346_ _0798_ _1133_ _1139_ VGND VGND VPWR VPWR _1140_ sky130_fd_sc_hd__and3_1
X_2277_ u_tx_fifo.mem\[4\]\[2\] u_tx_fifo.mem\[5\]\[2\] u_tx_fifo.mem\[6\]\[2\] u_tx_fifo.mem\[7\]\[2\]
+ net68 net64 VGND VGND VPWR VPWR _1085_ sky130_fd_sc_hd__mux4_1
XTAP_TAPCELL_ROW_55_728 VGND VPWR sky130_fd_sc_hd__tapvpwrvgnd_1
XFILLER_25_446 VGND VGND VPWR VPWR sky130_fd_sc_hd__fill_2
XFILLER_40_416 VGND VGND VPWR VPWR sky130_fd_sc_hd__decap_4
Xclkbuf_leaf_32_clk clknet_3_7__leaf_clk VGND VGND VPWR VPWR clknet_leaf_32_clk sky130_fd_sc_hd__clkbuf_8
XFILLER_33_490 VGND VGND VPWR VPWR sky130_fd_sc_hd__decap_8
XFILLER_40_449 VGND VGND VPWR VPWR sky130_fd_sc_hd__decap_8
XFILLER_52_287 VGND VGND VPWR VPWR sky130_fd_sc_hd__fill_1
XFILLER_20_151 VGND VGND VPWR VPWR sky130_fd_sc_hd__fill_1
XFILLER_4_306 VGND VGND VPWR VPWR sky130_fd_sc_hd__fill_2
XFILLER_0_501 VGND VGND VPWR VPWR sky130_fd_sc_hd__decap_3
XFILLER_0_545 VGND VGND VPWR VPWR sky130_fd_sc_hd__decap_8
XFILLER_87_162 VGND VGND VPWR VPWR sky130_fd_sc_hd__decap_6
XFILLER_57_55 VGND VGND VPWR VPWR sky130_fd_sc_hd__fill_1
XFILLER_90_305 VGND VGND VPWR VPWR sky130_fd_sc_hd__decap_3
XFILLER_63_519 VGND VGND VPWR VPWR sky130_fd_sc_hd__fill_1
XFILLER_28_262 VGND VGND VPWR VPWR sky130_fd_sc_hd__decap_4
XFILLER_28_295 VGND VGND VPWR VPWR sky130_fd_sc_hd__fill_2
XFILLER_43_232 VGND VGND VPWR VPWR sky130_fd_sc_hd__decap_4
XTAP_TAPCELL_ROW_26_452 VGND VPWR sky130_fd_sc_hd__tapvpwrvgnd_1
Xclkbuf_leaf_23_clk clknet_3_6__leaf_clk VGND VGND VPWR VPWR clknet_leaf_23_clk sky130_fd_sc_hd__clkbuf_8
XFILLER_3_372 VPWR VGND VPWR VGND sky130_ef_sc_hd__decap_12
XPHY_EDGE_ROW_13_Left_107 VGND VGND VPWR VPWR sky130_fd_sc_hd__decap_3
X_2200_ tag_raw\[7\] net531 net51 VGND VGND VPWR VPWR _0204_ sky130_fd_sc_hd__mux2_1
XFILLER_39_505 VGND VGND VPWR VPWR sky130_fd_sc_hd__decap_8
X_3180_ clknet_leaf_20_clk _0016_ net120 VGND VGND VPWR VPWR u_rx_fifo.wr_ptr\[0\]
+ sky130_fd_sc_hd__dfrtp_1
X_2131_ _1007_ _1008_ VGND VGND VPWR VPWR _1009_ sky130_fd_sc_hd__xnor2_2
XFILLER_39_549 VGND VGND VPWR VPWR sky130_fd_sc_hd__decap_6
X_2062_ net181 net33 _0960_ VGND VGND VPWR VPWR _0168_ sky130_fd_sc_hd__mux2_1
XFILLER_54_508 VGND VGND VPWR VPWR sky130_fd_sc_hd__decap_6
XFILLER_19_273 VGND VGND VPWR VPWR sky130_fd_sc_hd__decap_6
XPHY_EDGE_ROW_22_Left_116 VGND VGND VPWR VPWR sky130_fd_sc_hd__decap_3
X_2964_ net86 _1485_ _1486_ VGND VGND VPWR VPWR _0544_ sky130_fd_sc_hd__nor3_1
Xclkbuf_leaf_14_clk clknet_3_5__leaf_clk VGND VGND VPWR VPWR clknet_leaf_14_clk sky130_fd_sc_hd__clkbuf_8
X_1915_ u_parser.u_packet_encoder.tag_latched\[15\] _0894_ VGND VGND VPWR VPWR _0938_
+ sky130_fd_sc_hd__and2_1
XTAP_TAPCELL_ROW_60_775 VGND VPWR sky130_fd_sc_hd__tapvpwrvgnd_1
X_2895_ _1442_ _1443_ VGND VGND VPWR VPWR _0518_ sky130_fd_sc_hd__nor2_1
XFILLER_30_460 VGND VGND VPWR VPWR sky130_fd_sc_hd__decap_6
X_1846_ net238 net72 _0885_ VGND VGND VPWR VPWR _0027_ sky130_fd_sc_hd__mux2_1
X_1777_ u_uart_rx.low_count\[7\] u_uart_rx.low_count\[10\] u_uart_rx.low_count\[9\]
+ u_uart_rx.low_count\[8\] VGND VGND VPWR VPWR _0837_ sky130_fd_sc_hd__and4_1
X_3516_ clknet_leaf_25_clk _0343_ net136 VGND VGND VPWR VPWR u_parser.u_decoder.timeout_count\[18\]
+ sky130_fd_sc_hd__dfrtp_1
XPHY_EDGE_ROW_4_Right_4 VGND VGND VPWR VPWR sky130_fd_sc_hd__decap_3
XPHY_EDGE_ROW_31_Left_125 VGND VGND VPWR VPWR sky130_fd_sc_hd__decap_3
X_3447_ clknet_leaf_47_clk _0274_ net105 VGND VGND VPWR VPWR tag_raw\[1\] sky130_fd_sc_hd__dfrtp_1
X_3378_ clknet_leaf_54_clk _0211_ net98 VGND VGND VPWR VPWR u_parser.u_packet_encoder.tag_latched\[14\]
+ sky130_fd_sc_hd__dfrtp_1
XFILLER_69_140 VGND VGND VPWR VPWR sky130_fd_sc_hd__fill_1
X_2329_ net474 _1131_ net49 VGND VGND VPWR VPWR _0264_ sky130_fd_sc_hd__mux2_1
XFILLER_27_36 VGND VGND VPWR VPWR sky130_fd_sc_hd__decap_3
XPHY_EDGE_ROW_40_Left_134 VGND VGND VPWR VPWR sky130_fd_sc_hd__decap_3
XFILLER_25_254 VGND VGND VPWR VPWR sky130_fd_sc_hd__decap_6
XFILLER_53_552 VGND VGND VPWR VPWR sky130_fd_sc_hd__decap_3
XFILLER_80_382 VPWR VGND VPWR VGND sky130_ef_sc_hd__decap_12
XTAP_TAPCELL_ROW_23_422 VGND VPWR sky130_fd_sc_hd__tapvpwrvgnd_1
XFILLER_43_57 VPWR VGND VPWR VGND sky130_ef_sc_hd__decap_12
XFILLER_4_147 VGND VGND VPWR VPWR sky130_fd_sc_hd__fill_1
XFILLER_4_29 VGND VGND VPWR VPWR sky130_fd_sc_hd__decap_6
XTAP_TAPCELL_ROW_89_1044 VGND VPWR sky130_fd_sc_hd__tapvpwrvgnd_1
XFILLER_90_135 VGND VGND VPWR VPWR sky130_fd_sc_hd__decap_4
XFILLER_63_349 VGND VGND VPWR VPWR sky130_fd_sc_hd__decap_6
XFILLER_44_552 VGND VGND VPWR VPWR sky130_fd_sc_hd__decap_3
XFILLER_71_393 VGND VGND VPWR VPWR sky130_fd_sc_hd__decap_4
XFILLER_12_460 VPWR VGND VPWR VGND sky130_ef_sc_hd__decap_12
X_2680_ u_parser.u_decoder.decoded_checksum_calc\[4\] _1358_ net9 VGND VGND VPWR VPWR
+ _0388_ sky130_fd_sc_hd__mux2_1
X_1700_ _0765_ _0766_ net145 VGND VGND VPWR VPWR _0767_ sky130_fd_sc_hd__mux2_1
X_1631_ _0667_ u_uart_rx.state\[3\] _0700_ u_uart_rx.state\[2\] VGND VGND VPWR VPWR
+ _0701_ sky130_fd_sc_hd__a22o_1
XFILLER_8_475 VGND VGND VPWR VPWR sky130_fd_sc_hd__fill_1
X_3301_ clknet_leaf_65_clk _0137_ VGND VGND VPWR VPWR u_tx_fifo.mem\[14\]\[4\] sky130_fd_sc_hd__dfxtp_1
XFILLER_86_419 VGND VGND VPWR VPWR sky130_fd_sc_hd__fill_1
Xclkbuf_leaf_3_clk clknet_3_1__leaf_clk VGND VGND VPWR VPWR clknet_leaf_3_clk sky130_fd_sc_hd__clkbuf_8
X_3232_ clknet_leaf_10_clk _0068_ VGND VGND VPWR VPWR u_rx_fifo.mem\[10\]\[7\] sky130_fd_sc_hd__dfxtp_1
X_3163_ net198 net22 _1585_ VGND VGND VPWR VPWR _0644_ sky130_fd_sc_hd__mux2_1
X_2114_ _0983_ _0991_ VGND VGND VPWR VPWR _0992_ sky130_fd_sc_hd__xnor2_2
X_3094_ _1549_ _1547_ u_uart_rx.sample_div_count\[13\] VGND VGND VPWR VPWR _0611_
+ sky130_fd_sc_hd__mux2_1
XTAP_TAPCELL_ROW_65_823 VGND VPWR sky130_fd_sc_hd__tapvpwrvgnd_1
X_2045_ net334 net77 _0958_ VGND VGND VPWR VPWR _0153_ sky130_fd_sc_hd__mux2_1
XFILLER_54_349 VGND VGND VPWR VPWR sky130_fd_sc_hd__decap_6
XFILLER_22_213 VGND VGND VPWR VPWR sky130_fd_sc_hd__decap_3
XFILLER_22_224 VGND VGND VPWR VPWR sky130_fd_sc_hd__fill_2
Xfanout28 _0908_ VGND VGND VPWR VPWR net28 sky130_fd_sc_hd__buf_1
Xfanout17 net18 VGND VGND VPWR VPWR net17 sky130_fd_sc_hd__clkbuf_4
XFILLER_50_522 VGND VGND VPWR VPWR sky130_fd_sc_hd__fill_1
XFILLER_50_533 VPWR VGND VPWR VGND sky130_ef_sc_hd__decap_12
Xfanout39 _0760_ VGND VGND VPWR VPWR net39 sky130_fd_sc_hd__clkbuf_2
X_2947_ u_uart_rx.low_count\[4\] _1475_ VGND VGND VPWR VPWR _1476_ sky130_fd_sc_hd__and2_1
X_2878_ net229 net20 _1437_ VGND VGND VPWR VPWR _0507_ sky130_fd_sc_hd__mux2_1
Xhold420 u_uart_tx.clk_count\[15\] VGND VGND VPWR VPWR net576 sky130_fd_sc_hd__dlygate4sd3_1
X_1829_ u_rx_fifo.wr_ptr\[3\] _0871_ VGND VGND VPWR VPWR _0877_ sky130_fd_sc_hd__or2_1
Xhold431 u_rx_fifo.level\[0\] VGND VGND VPWR VPWR net587 sky130_fd_sc_hd__dlygate4sd3_1
Xhold442 u_parser.u_decoder.decoded_checksum_calc\[6\] VGND VGND VPWR VPWR net598
+ sky130_fd_sc_hd__dlygate4sd3_1
Xhold453 u_parser.u_decoder.ascii_buf\[8\]\[4\] VGND VGND VPWR VPWR net609 sky130_fd_sc_hd__dlygate4sd3_1
Xhold486 u_uart_rx.sample_div_count\[8\] VGND VGND VPWR VPWR net642 sky130_fd_sc_hd__dlygate4sd3_1
Xhold464 u_uart_rx.state\[1\] VGND VGND VPWR VPWR net620 sky130_fd_sc_hd__dlygate4sd3_1
Xhold475 u_parser.u_decoder.ascii_buf\[11\]\[6\] VGND VGND VPWR VPWR net631 sky130_fd_sc_hd__dlygate4sd3_1
Xhold497 u_parser.u_decoder.ascii_buf\[8\]\[2\] VGND VGND VPWR VPWR net653 sky130_fd_sc_hd__dlygate4sd3_1
XFILLER_57_121 VGND VGND VPWR VPWR sky130_fd_sc_hd__decap_8
XPHY_EDGE_ROW_79_Right_79 VGND VGND VPWR VPWR sky130_fd_sc_hd__decap_3
XTAP_TAPCELL_ROW_0_194 VGND VPWR sky130_fd_sc_hd__tapvpwrvgnd_1
XFILLER_53_393 VGND VGND VPWR VPWR sky130_fd_sc_hd__decap_3
XFILLER_54_67 VGND VGND VPWR VPWR sky130_fd_sc_hd__decap_4
XFILLER_13_257 VGND VGND VPWR VPWR sky130_fd_sc_hd__fill_2
XPHY_EDGE_ROW_88_Right_88 VGND VGND VPWR VPWR sky130_fd_sc_hd__decap_3
XFILLER_79_86 VGND VGND VPWR VPWR sky130_fd_sc_hd__fill_1
XTAP_TAPCELL_ROW_79_948 VGND VPWR sky130_fd_sc_hd__tapvpwrvgnd_1
XFILLER_48_121 VPWR VGND VPWR VGND sky130_ef_sc_hd__decap_12
XFILLER_63_135 VGND VGND VPWR VPWR sky130_fd_sc_hd__fill_1
XFILLER_32_533 VPWR VGND VPWR VGND sky130_ef_sc_hd__decap_12
XTAP_TAPCELL_ROW_34_528 VGND VPWR sky130_fd_sc_hd__tapvpwrvgnd_1
X_3781_ clknet_leaf_28_clk _0599_ net138 VGND VGND VPWR VPWR u_uart_rx.sample_div_count\[1\]
+ sky130_fd_sc_hd__dfrtp_1
X_2801_ u_parser.u_decoder.ascii_buf\[2\]\[1\] net38 _1410_ VGND VGND VPWR VPWR _0457_
+ sky130_fd_sc_hd__mux2_1
XTAP_TAPCELL_ROW_70_870 VGND VPWR sky130_fd_sc_hd__tapvpwrvgnd_1
X_2732_ net616 _1375_ VGND VGND VPWR VPWR _0423_ sky130_fd_sc_hd__and2_1
XFILLER_74_3 VPWR VGND VPWR VGND sky130_ef_sc_hd__decap_12
XFILLER_8_261 VGND VGND VPWR VPWR sky130_fd_sc_hd__fill_2
X_2663_ _1343_ _1344_ VGND VGND VPWR VPWR _1345_ sky130_fd_sc_hd__xnor2_1
X_2594_ net492 _1291_ net11 VGND VGND VPWR VPWR _0369_ sky130_fd_sc_hd__mux2_1
X_1614_ u_parser.u_decoder.ascii_buf\[3\]\[0\] VGND VGND VPWR VPWR _0684_ sky130_fd_sc_hd__inv_2
XFILLER_59_408 VPWR VGND VPWR VGND sky130_ef_sc_hd__decap_12
X_3215_ clknet_leaf_21_clk _0051_ VGND VGND VPWR VPWR u_rx_fifo.mem\[13\]\[6\] sky130_fd_sc_hd__dfxtp_1
X_3146_ net59 _1575_ _1577_ _1579_ VGND VGND VPWR VPWR _0633_ sky130_fd_sc_hd__a31o_1
X_3077_ u_uart_rx.sample_div_count\[7\] u_uart_rx.sample_div_count\[8\] _1534_ VGND
+ VGND VPWR VPWR _1538_ sky130_fd_sc_hd__and3_1
XFILLER_82_477 VPWR VGND VPWR VGND sky130_ef_sc_hd__decap_12
X_2028_ net259 net21 _0956_ VGND VGND VPWR VPWR _0138_ sky130_fd_sc_hd__mux2_1
XFILLER_35_393 VPWR VGND VPWR VGND sky130_ef_sc_hd__decap_12
Xhold250 u_rx_fifo.mem\[7\]\[2\] VGND VGND VPWR VPWR net406 sky130_fd_sc_hd__dlygate4sd3_1
Xhold261 u_tx_fifo.mem\[1\]\[6\] VGND VGND VPWR VPWR net417 sky130_fd_sc_hd__dlygate4sd3_1
Xhold294 u_parser.u_decoder.decoded_payload\[18\] VGND VGND VPWR VPWR net450 sky130_fd_sc_hd__dlygate4sd3_1
Xhold283 tag_raw\[24\] VGND VGND VPWR VPWR net439 sky130_fd_sc_hd__dlygate4sd3_1
Xhold272 u_parser.u_decoder.ascii_buf\[9\]\[2\] VGND VGND VPWR VPWR net428 sky130_fd_sc_hd__dlygate4sd3_1
XTAP_TAPCELL_ROW_5_253 VGND VPWR sky130_fd_sc_hd__tapvpwrvgnd_1
XFILLER_58_485 VGND VGND VPWR VPWR sky130_fd_sc_hd__decap_3
XTAP_TAPCELL_ROW_86_1014 VGND VPWR sky130_fd_sc_hd__tapvpwrvgnd_1
XFILLER_45_113 VGND VGND VPWR VPWR sky130_fd_sc_hd__decap_4
XFILLER_58_496 VPWR VGND VPWR VGND sky130_ef_sc_hd__decap_12
XFILLER_65_55 VGND VGND VPWR VPWR sky130_fd_sc_hd__fill_1
XFILLER_65_88 VGND VGND VPWR VPWR sky130_fd_sc_hd__decap_4
XTAP_TAPCELL_ROW_84_995 VGND VPWR sky130_fd_sc_hd__tapvpwrvgnd_1
XFILLER_33_319 VPWR VGND VPWR VGND sky130_ef_sc_hd__decap_12
XFILLER_14_533 VPWR VGND VPWR VGND sky130_ef_sc_hd__decap_12
XFILLER_81_87 VGND VGND VPWR VPWR sky130_fd_sc_hd__fill_1
X_3000_ net214 net25 _1504_ VGND VGND VPWR VPWR _0562_ sky130_fd_sc_hd__mux2_1
XFILLER_76_271 VGND VGND VPWR VPWR sky130_fd_sc_hd__decap_4
XFILLER_49_496 VGND VGND VPWR VPWR sky130_fd_sc_hd__decap_8
XFILLER_64_477 VGND VGND VPWR VPWR sky130_fd_sc_hd__decap_8
XFILLER_51_105 VGND VGND VPWR VPWR sky130_fd_sc_hd__decap_6
XFILLER_51_149 VGND VGND VPWR VPWR sky130_fd_sc_hd__decap_8
X_3833_ clknet_leaf_65_clk _0649_ VGND VGND VPWR VPWR u_tx_fifo.mem\[11\]\[2\] sky130_fd_sc_hd__dfxtp_1
X_3764_ clknet_leaf_11_clk _0582_ VGND VGND VPWR VPWR u_rx_fifo.mem\[9\]\[5\] sky130_fd_sc_hd__dfxtp_1
X_3695_ clknet_leaf_50_clk _0519_ net92 VGND VGND VPWR VPWR u_uart_tx.clk_count\[2\]
+ sky130_fd_sc_hd__dfrtp_1
X_2715_ _0964_ _1142_ VGND VGND VPWR VPWR _1374_ sky130_fd_sc_hd__nor2_2
X_2646_ net458 _1332_ net7 VGND VGND VPWR VPWR _0380_ sky130_fd_sc_hd__mux2_1
X_2577_ _1274_ _1277_ VGND VGND VPWR VPWR _1278_ sky130_fd_sc_hd__and2_1
XFILLER_19_15 VGND VGND VPWR VPWR sky130_fd_sc_hd__decap_8
XFILLER_19_48 VGND VGND VPWR VPWR sky130_fd_sc_hd__decap_8
XFILLER_55_400 VGND VGND VPWR VPWR sky130_fd_sc_hd__fill_2
XFILLER_74_219 VGND VGND VPWR VPWR sky130_fd_sc_hd__decap_8
XTAP_TAPCELL_ROW_2_223 VGND VPWR sky130_fd_sc_hd__tapvpwrvgnd_1
XFILLER_27_113 VGND VGND VPWR VPWR sky130_fd_sc_hd__decap_6
X_3129_ _1565_ _1566_ VGND VGND VPWR VPWR _1567_ sky130_fd_sc_hd__or2_1
XFILLER_55_499 VGND VGND VPWR VPWR sky130_fd_sc_hd__decap_4
XFILLER_42_149 VGND VGND VPWR VPWR sky130_fd_sc_hd__fill_1
XFILLER_11_503 VGND VGND VPWR VPWR sky130_fd_sc_hd__fill_1
XFILLER_7_529 VPWR VGND VPWR VGND sky130_ef_sc_hd__decap_12
XFILLER_51_57 VPWR VGND VPWR VGND sky130_ef_sc_hd__decap_12
XFILLER_4_3 VPWR VGND VPWR VGND sky130_ef_sc_hd__decap_12
XTAP_TAPCELL_ROW_92_1073 VGND VPWR sky130_fd_sc_hd__tapvpwrvgnd_1
XFILLER_93_517 VPWR VGND VPWR VGND sky130_ef_sc_hd__decap_12
XFILLER_58_293 VGND VGND VPWR VPWR sky130_fd_sc_hd__decap_8
XFILLER_92_53 VPWR VGND VPWR VGND sky130_ef_sc_hd__decap_12
XTAP_TAPCELL_ROW_44_623 VGND VPWR sky130_fd_sc_hd__tapvpwrvgnd_1
XTAP_TAPCELL_ROW_16_358 VGND VPWR sky130_fd_sc_hd__tapvpwrvgnd_1
XFILLER_14_352 VGND VGND VPWR VPWR sky130_fd_sc_hd__decap_4
XFILLER_41_182 VPWR VGND VPWR VGND sky130_ef_sc_hd__decap_12
X_3480_ clknet_leaf_43_clk _0307_ net111 VGND VGND VPWR VPWR tag_raw\[34\] sky130_fd_sc_hd__dfrtp_4
XFILLER_41_90 VGND VGND VPWR VPWR sky130_fd_sc_hd__decap_8
X_2500_ _1216_ _1217_ VGND VGND VPWR VPWR _1218_ sky130_fd_sc_hd__and2_1
X_2431_ net604 _1165_ _1166_ VGND VGND VPWR VPWR _0331_ sky130_fd_sc_hd__a21oi_1
XFILLER_37_3 VPWR VGND VPWR VGND sky130_ef_sc_hd__decap_12
X_2362_ tag_raw\[15\] net456 _1140_ VGND VGND VPWR VPWR _0288_ sky130_fd_sc_hd__mux2_1
X_2293_ net497 _1099_ net49 VGND VGND VPWR VPWR _0260_ sky130_fd_sc_hd__mux2_1
XFILLER_24_149 VGND VGND VPWR VPWR sky130_fd_sc_hd__decap_3
XFILLER_52_436 VGND VGND VPWR VPWR sky130_fd_sc_hd__decap_6
X_3816_ clknet_leaf_18_clk _0632_ net120 VGND VGND VPWR VPWR u_uart_rx.rx_shift\[1\]
+ sky130_fd_sc_hd__dfrtp_1
XFILLER_20_355 VGND VGND VPWR VPWR sky130_fd_sc_hd__fill_1
X_3747_ clknet_leaf_3_clk net160 VGND VGND VPWR VPWR startup_reset\[2\] sky130_fd_sc_hd__dfxtp_1
X_3678_ clknet_leaf_63_clk _0505_ VGND VGND VPWR VPWR u_tx_fifo.mem\[10\]\[4\] sky130_fd_sc_hd__dfxtp_1
X_2629_ u_parser.u_decoder.ascii_buf\[1\]\[1\] _1312_ VGND VGND VPWR VPWR _1319_ sky130_fd_sc_hd__xnor2_1
XFILLER_28_411 VGND VGND VPWR VPWR sky130_fd_sc_hd__fill_2
XTAP_TAPCELL_ROW_58_748 VGND VPWR sky130_fd_sc_hd__tapvpwrvgnd_1
XFILLER_28_455 VGND VGND VPWR VPWR sky130_fd_sc_hd__fill_1
Xmax_cap47 _1209_ VGND VGND VPWR VPWR net47 sky130_fd_sc_hd__clkbuf_1
XTAP_TAPCELL_ROW_13_328 VGND VPWR sky130_fd_sc_hd__tapvpwrvgnd_1
XFILLER_11_322 VGND VGND VPWR VPWR sky130_fd_sc_hd__decap_4
XFILLER_87_53 VGND VGND VPWR VPWR sky130_fd_sc_hd__decap_3
X_2980_ net521 _1496_ _1497_ VGND VGND VPWR VPWR _0549_ sky130_fd_sc_hd__a21oi_1
X_1931_ net78 net408 _0874_ VGND VGND VPWR VPWR _0056_ sky130_fd_sc_hd__mux2_1
X_1862_ u_tx_fifo.wr_ptr\[3\] _0891_ VGND VGND VPWR VPWR _0892_ sky130_fd_sc_hd__or2_4
X_3601_ clknet_leaf_8_clk _0428_ net115 VGND VGND VPWR VPWR u_parser.u_decoder.ascii_buf\[8\]\[4\]
+ sky130_fd_sc_hd__dfrtp_1
X_1793_ rx_fifo_in_valid _0847_ VGND VGND VPWR VPWR _0849_ sky130_fd_sc_hd__nand2_1
X_3532_ clknet_leaf_39_clk _0359_ net119 VGND VGND VPWR VPWR u_parser.u_decoder.decoded_payload\[15\]
+ sky130_fd_sc_hd__dfrtp_1
X_3463_ clknet_leaf_45_clk _0290_ net109 VGND VGND VPWR VPWR tag_raw\[17\] sky130_fd_sc_hd__dfrtp_1
X_2414_ net623 _1154_ _1153_ VGND VGND VPWR VPWR _0325_ sky130_fd_sc_hd__o21ba_1
X_3394_ clknet_leaf_57_clk _0227_ net97 VGND VGND VPWR VPWR u_parser.u_packet_encoder.tag_latched\[30\]
+ sky130_fd_sc_hd__dfrtp_1
X_2345_ _0806_ _1134_ _1136_ _1138_ VGND VGND VPWR VPWR _1139_ sky130_fd_sc_hd__and4_1
X_2276_ u_tx_fifo.mem\[0\]\[2\] u_tx_fifo.mem\[1\]\[2\] u_tx_fifo.mem\[2\]\[2\] u_tx_fifo.mem\[3\]\[2\]
+ net69 net65 VGND VGND VPWR VPWR _1084_ sky130_fd_sc_hd__mux4_1
XFILLER_80_553 VGND VGND VPWR VPWR sky130_fd_sc_hd__fill_2
XFILLER_32_15 VPWR VGND VPWR VGND sky130_ef_sc_hd__decap_12
XFILLER_28_230 VGND VGND VPWR VPWR sky130_fd_sc_hd__fill_1
XFILLER_83_391 VGND VGND VPWR VPWR sky130_fd_sc_hd__fill_1
XTAP_TAPCELL_ROW_26_453 VGND VPWR sky130_fd_sc_hd__tapvpwrvgnd_1
XFILLER_7_167 VGND VGND VPWR VPWR sky130_fd_sc_hd__fill_1
XFILLER_3_384 VGND VGND VPWR VPWR sky130_fd_sc_hd__decap_8
XFILLER_78_152 VGND VGND VPWR VPWR sky130_fd_sc_hd__fill_1
XFILLER_78_130 VGND VGND VPWR VPWR sky130_fd_sc_hd__fill_1
XFILLER_78_174 VGND VGND VPWR VPWR sky130_fd_sc_hd__decap_4
X_2130_ tag_raw\[15\] _0979_ VGND VGND VPWR VPWR _1008_ sky130_fd_sc_hd__xor2_1
X_2061_ net197 net23 _0960_ VGND VGND VPWR VPWR _0167_ sky130_fd_sc_hd__mux2_1
XFILLER_62_542 VPWR VGND VPWR VGND sky130_ef_sc_hd__decap_12
X_2963_ u_uart_rx.low_count\[10\] u_uart_rx.low_count\[9\] _1483_ VGND VGND VPWR VPWR
+ _1486_ sky130_fd_sc_hd__and3_1
X_1914_ u_parser.u_packet_encoder.tag_latched\[23\] _0899_ _0902_ u_parser.u_packet_encoder.tag_latched\[7\]
+ VGND VGND VPWR VPWR _0937_ sky130_fd_sc_hd__a22o_1
X_2894_ net622 _1439_ net6 VGND VGND VPWR VPWR _1443_ sky130_fd_sc_hd__o21ai_1
XTAP_TAPCELL_ROW_60_776 VGND VPWR sky130_fd_sc_hd__tapvpwrvgnd_1
X_1845_ net340 net75 _0885_ VGND VGND VPWR VPWR _0026_ sky130_fd_sc_hd__mux2_1
XFILLER_30_494 VGND VGND VPWR VPWR sky130_fd_sc_hd__decap_4
X_1776_ _0825_ _0826_ u_uart_tx.state\[0\] VGND VGND VPWR VPWR _0657_ sky130_fd_sc_hd__nor3b_1
X_3515_ clknet_leaf_25_clk _0342_ net136 VGND VGND VPWR VPWR u_parser.u_decoder.timeout_count\[17\]
+ sky130_fd_sc_hd__dfrtp_1
XFILLER_89_406 VGND VGND VPWR VPWR sky130_fd_sc_hd__fill_2
X_3446_ clknet_leaf_46_clk _0273_ net104 VGND VGND VPWR VPWR tag_raw\[0\] sky130_fd_sc_hd__dfrtp_1
X_3377_ clknet_leaf_40_clk _0210_ net106 VGND VGND VPWR VPWR u_parser.u_packet_encoder.tag_latched\[13\]
+ sky130_fd_sc_hd__dfrtp_1
X_2328_ _0682_ _1126_ _1129_ _1130_ VGND VGND VPWR VPWR _1131_ sky130_fd_sc_hd__a22o_1
XFILLER_27_15 VGND VGND VPWR VPWR sky130_fd_sc_hd__decap_4
XTAP_TAPCELL_ROW_68_843 VGND VPWR sky130_fd_sc_hd__tapvpwrvgnd_1
X_2259_ u_tx_fifo.mem\[4\]\[0\] u_tx_fifo.mem\[5\]\[0\] u_tx_fifo.mem\[6\]\[0\] u_tx_fifo.mem\[7\]\[0\]
+ net68 net64 VGND VGND VPWR VPWR _1069_ sky130_fd_sc_hd__mux4_1
XFILLER_25_222 VGND VGND VPWR VPWR sky130_fd_sc_hd__fill_2
XFILLER_80_394 VPWR VGND VPWR VGND sky130_ef_sc_hd__decap_12
XFILLER_13_417 VGND VGND VPWR VPWR sky130_fd_sc_hd__decap_8
XTAP_TAPCELL_ROW_23_423 VGND VPWR sky130_fd_sc_hd__tapvpwrvgnd_1
XFILLER_43_69 VPWR VGND VPWR VGND sky130_ef_sc_hd__decap_12
XFILLER_0_321 VPWR VGND VPWR VGND sky130_ef_sc_hd__decap_12
XFILLER_0_365 VPWR VGND VPWR VGND sky130_ef_sc_hd__decap_12
XTAP_TAPCELL_ROW_89_1045 VGND VPWR sky130_fd_sc_hd__tapvpwrvgnd_1
XFILLER_36_509 VPWR VGND VPWR VGND sky130_ef_sc_hd__decap_12
XFILLER_90_147 VGND VGND VPWR VPWR sky130_fd_sc_hd__fill_1
XFILLER_44_520 VGND VGND VPWR VPWR sky130_fd_sc_hd__fill_2
XFILLER_75_199 VGND VGND VPWR VPWR sky130_fd_sc_hd__decap_6
XFILLER_90_169 VGND VGND VPWR VPWR sky130_fd_sc_hd__fill_2
XFILLER_16_288 VGND VGND VPWR VPWR sky130_fd_sc_hd__decap_3
XFILLER_12_472 VGND VGND VPWR VPWR sky130_fd_sc_hd__decap_4
XFILLER_8_421 VPWR VGND VPWR VGND sky130_ef_sc_hd__decap_12
X_1630_ u_uart_rx.bit_index\[2\] u_uart_rx.bit_index\[1\] u_uart_rx.bit_index\[0\]
+ VGND VGND VPWR VPWR _0700_ sky130_fd_sc_hd__nand3_1
X_3300_ clknet_leaf_0_clk _0136_ VGND VGND VPWR VPWR u_tx_fifo.mem\[14\]\[3\] sky130_fd_sc_hd__dfxtp_1
X_3231_ clknet_leaf_10_clk _0067_ VGND VGND VPWR VPWR u_rx_fifo.mem\[10\]\[6\] sky130_fd_sc_hd__dfxtp_1
XFILLER_79_494 VGND VGND VPWR VPWR sky130_fd_sc_hd__fill_2
X_3162_ net174 net32 _1585_ VGND VGND VPWR VPWR _0643_ sky130_fd_sc_hd__mux2_1
XFILLER_66_111 VGND VGND VPWR VPWR sky130_fd_sc_hd__fill_2
X_2113_ tag_raw\[25\] _0990_ VGND VGND VPWR VPWR _0991_ sky130_fd_sc_hd__xnor2_1
X_3093_ u_uart_rx.sample_div_count\[11\] u_uart_rx.sample_div_count\[12\] _1545_ VGND
+ VGND VPWR VPWR _1549_ sky130_fd_sc_hd__and3_1
X_2044_ net239 net79 _0958_ VGND VGND VPWR VPWR _0152_ sky130_fd_sc_hd__mux2_1
Xfanout29 net30 VGND VGND VPWR VPWR net29 sky130_fd_sc_hd__clkbuf_2
Xfanout18 _1140_ VGND VGND VPWR VPWR net18 sky130_fd_sc_hd__clkbuf_4
XFILLER_50_545 VGND VGND VPWR VPWR sky130_fd_sc_hd__decap_8
X_2946_ net87 _1474_ _1475_ VGND VGND VPWR VPWR _0537_ sky130_fd_sc_hd__nor3_1
X_2877_ net176 net21 _1437_ VGND VGND VPWR VPWR _0506_ sky130_fd_sc_hd__mux2_1
X_1828_ u_rx_fifo.wr_ptr\[3\] _0871_ VGND VGND VPWR VPWR _0876_ sky130_fd_sc_hd__nand2_4
Xhold410 u_parser.u_decoder.ascii_buf\[2\]\[4\] VGND VGND VPWR VPWR net566 sky130_fd_sc_hd__dlygate4sd3_1
X_1759_ u_uart_tx.clk_count\[5\] u_uart_tx.clk_count\[4\] u_uart_tx.clk_count\[6\]
+ VGND VGND VPWR VPWR _0822_ sky130_fd_sc_hd__a21o_1
Xhold421 u_parser.u_decoder.ascii_buf\[5\]\[5\] VGND VGND VPWR VPWR net577 sky130_fd_sc_hd__dlygate4sd3_1
Xhold443 u_parser.u_decoder.ascii_buf\[9\]\[5\] VGND VGND VPWR VPWR net599 sky130_fd_sc_hd__dlygate4sd3_1
Xhold454 u_parser.u_decoder.ascii_buf\[0\]\[5\] VGND VGND VPWR VPWR net610 sky130_fd_sc_hd__dlygate4sd3_1
Xhold432 u_parser.u_decoder.decoded_checksum_rx\[0\] VGND VGND VPWR VPWR net588 sky130_fd_sc_hd__dlygate4sd3_1
XFILLER_89_225 VGND VGND VPWR VPWR sky130_fd_sc_hd__fill_1
Xhold476 u_uart_tx.clk_count\[13\] VGND VGND VPWR VPWR net632 sky130_fd_sc_hd__dlygate4sd3_1
Xhold487 u_uart_tx.bit_index\[2\] VGND VGND VPWR VPWR net643 sky130_fd_sc_hd__dlygate4sd3_1
Xhold465 u_rx_fifo.wr_ptr\[1\] VGND VGND VPWR VPWR net621 sky130_fd_sc_hd__dlygate4sd3_1
X_3429_ clknet_leaf_60_clk _0262_ net88 VGND VGND VPWR VPWR u_uart_tx.tx_data\[5\]
+ sky130_fd_sc_hd__dfrtp_1
Xhold498 u_uart_rx.low_count\[9\] VGND VGND VPWR VPWR net654 sky130_fd_sc_hd__dlygate4sd3_1
XFILLER_57_111 VGND VGND VPWR VPWR sky130_fd_sc_hd__fill_1
XFILLER_85_431 VPWR VGND VPWR VGND sky130_ef_sc_hd__decap_12
XFILLER_45_306 VGND VGND VPWR VPWR sky130_fd_sc_hd__decap_4
XFILLER_57_177 VGND VGND VPWR VPWR sky130_fd_sc_hd__fill_2
XFILLER_38_391 VGND VGND VPWR VPWR sky130_fd_sc_hd__fill_1
XFILLER_26_553 VGND VGND VPWR VPWR sky130_fd_sc_hd__fill_2
XFILLER_60_309 VGND VGND VPWR VPWR sky130_fd_sc_hd__decap_6
XTAP_TAPCELL_ROW_0_195 VGND VPWR sky130_fd_sc_hd__tapvpwrvgnd_1
XFILLER_70_78 VGND VGND VPWR VPWR sky130_fd_sc_hd__fill_1
XTAP_TAPCELL_ROW_79_949 VGND VPWR sky130_fd_sc_hd__tapvpwrvgnd_1
XTAP_TAPCELL_ROW_8_273 VGND VPWR sky130_fd_sc_hd__tapvpwrvgnd_1
XFILLER_48_133 VGND VGND VPWR VPWR sky130_fd_sc_hd__decap_6
XFILLER_76_475 VGND VGND VPWR VPWR sky130_fd_sc_hd__fill_1
XFILLER_36_306 VGND VGND VPWR VPWR sky130_fd_sc_hd__fill_2
XFILLER_63_103 VGND VGND VPWR VPWR sky130_fd_sc_hd__decap_8
XFILLER_17_531 VPWR VGND VPWR VGND sky130_ef_sc_hd__decap_12
XFILLER_29_380 VPWR VGND VPWR VGND sky130_ef_sc_hd__decap_12
XFILLER_63_169 VGND VGND VPWR VPWR sky130_fd_sc_hd__fill_2
XTAP_TAPCELL_ROW_34_529 VGND VPWR sky130_fd_sc_hd__tapvpwrvgnd_1
XFILLER_32_545 VGND VGND VPWR VPWR sky130_fd_sc_hd__decap_8
X_3780_ clknet_leaf_28_clk _0598_ net138 VGND VGND VPWR VPWR u_uart_rx.sample_div_count\[0\]
+ sky130_fd_sc_hd__dfrtp_1
X_2800_ u_parser.u_decoder.ascii_buf\[2\]\[0\] net40 _1410_ VGND VGND VPWR VPWR _0456_
+ sky130_fd_sc_hd__mux2_1
XTAP_TAPCELL_ROW_70_871 VGND VPWR sky130_fd_sc_hd__tapvpwrvgnd_1
X_2731_ _0744_ net644 _1375_ VGND VGND VPWR VPWR _0422_ sky130_fd_sc_hd__mux2_1
X_2662_ _1203_ _1233_ VGND VGND VPWR VPWR _1344_ sky130_fd_sc_hd__xor2_1
XFILLER_67_3 VPWR VGND VPWR VGND sky130_ef_sc_hd__decap_12
X_1613_ u_parser.u_decoder.ascii_buf\[5\]\[0\] VGND VGND VPWR VPWR _0683_ sky130_fd_sc_hd__inv_2
X_2593_ _1287_ _1290_ VGND VGND VPWR VPWR _1291_ sky130_fd_sc_hd__and2_1
X_3214_ clknet_leaf_8_clk _0050_ VGND VGND VPWR VPWR u_rx_fifo.mem\[13\]\[5\] sky130_fd_sc_hd__dfxtp_1
XFILLER_39_111 VGND VGND VPWR VPWR sky130_fd_sc_hd__fill_1
XFILLER_67_442 VGND VGND VPWR VPWR sky130_fd_sc_hd__decap_6
X_3145_ _1573_ _1578_ net547 VGND VGND VPWR VPWR _1579_ sky130_fd_sc_hd__o21a_1
XFILLER_27_306 VGND VGND VPWR VPWR sky130_fd_sc_hd__decap_3
X_3076_ _1513_ _1535_ _1537_ VGND VGND VPWR VPWR _0605_ sky130_fd_sc_hd__and3_1
XFILLER_67_497 VGND VGND VPWR VPWR sky130_fd_sc_hd__decap_6
X_2027_ net221 net31 _0956_ VGND VGND VPWR VPWR _0137_ sky130_fd_sc_hd__mux2_1
XFILLER_42_309 VGND VGND VPWR VPWR sky130_fd_sc_hd__decap_8
XFILLER_82_489 VGND VGND VPWR VPWR sky130_fd_sc_hd__decap_3
X_2929_ _0669_ _1465_ net6 VGND VGND VPWR VPWR _0530_ sky130_fd_sc_hd__a21boi_1
XFILLER_40_15 VPWR VGND VPWR VGND sky130_ef_sc_hd__decap_12
Xhold240 u_rx_fifo.mem\[3\]\[1\] VGND VGND VPWR VPWR net396 sky130_fd_sc_hd__dlygate4sd3_1
Xhold262 u_tx_fifo.mem\[15\]\[5\] VGND VGND VPWR VPWR net418 sky130_fd_sc_hd__dlygate4sd3_1
Xhold251 u_parser.u_decoder.decoded_payload\[2\] VGND VGND VPWR VPWR net407 sky130_fd_sc_hd__dlygate4sd3_1
Xhold284 u_uart_rx.low_count\[17\] VGND VGND VPWR VPWR net440 sky130_fd_sc_hd__dlygate4sd3_1
Xhold295 _0291_ VGND VGND VPWR VPWR net451 sky130_fd_sc_hd__dlygate4sd3_1
Xhold273 u_parser.u_packet_encoder.tag_latched\[14\] VGND VGND VPWR VPWR net429 sky130_fd_sc_hd__dlygate4sd3_1
XFILLER_49_57 VPWR VGND VPWR VGND sky130_ef_sc_hd__decap_12
XTAP_TAPCELL_ROW_76_919 VGND VPWR sky130_fd_sc_hd__tapvpwrvgnd_1
XFILLER_18_306 VGND VGND VPWR VPWR sky130_fd_sc_hd__fill_2
XTAP_TAPCELL_ROW_86_1015 VGND VPWR sky130_fd_sc_hd__tapvpwrvgnd_1
XFILLER_45_125 VGND VGND VPWR VPWR sky130_fd_sc_hd__decap_3
XFILLER_45_136 VGND VGND VPWR VPWR sky130_fd_sc_hd__decap_3
XFILLER_45_169 VGND VGND VPWR VPWR sky130_fd_sc_hd__decap_3
XTAP_TAPCELL_ROW_84_996 VGND VPWR sky130_fd_sc_hd__tapvpwrvgnd_1
XFILLER_14_512 VPWR VGND VPWR VGND sky130_ef_sc_hd__decap_12
XFILLER_14_545 VGND VGND VPWR VPWR sky130_fd_sc_hd__decap_8
XFILLER_60_139 VGND VGND VPWR VPWR sky130_fd_sc_hd__fill_1
XFILLER_81_66 VGND VGND VPWR VPWR sky130_fd_sc_hd__decap_8
XFILLER_5_232 VGND VGND VPWR VPWR sky130_fd_sc_hd__fill_1
XFILLER_49_442 VGND VGND VPWR VPWR sky130_fd_sc_hd__decap_6
XTAP_TAPCELL_ROW_19_378 VGND VPWR sky130_fd_sc_hd__tapvpwrvgnd_1
XFILLER_44_191 VGND VGND VPWR VPWR sky130_fd_sc_hd__decap_4
X_3832_ clknet_leaf_62_clk _0648_ VGND VGND VPWR VPWR u_tx_fifo.mem\[11\]\[1\] sky130_fd_sc_hd__dfxtp_1
XFILLER_20_515 VPWR VGND VPWR VGND sky130_ef_sc_hd__decap_12
X_3763_ clknet_leaf_11_clk _0581_ VGND VGND VPWR VPWR u_rx_fifo.mem\[9\]\[4\] sky130_fd_sc_hd__dfxtp_1
X_3694_ clknet_leaf_50_clk _0518_ net91 VGND VGND VPWR VPWR u_uart_tx.clk_count\[1\]
+ sky130_fd_sc_hd__dfrtp_1
X_2714_ net595 _1373_ VGND VGND VPWR VPWR _0407_ sky130_fd_sc_hd__and2_1
X_2645_ u_parser.u_decoder.ascii_buf\[0\]\[0\] _1331_ _1328_ VGND VGND VPWR VPWR _1332_
+ sky130_fd_sc_hd__o21a_1
X_2576_ u_parser.u_decoder.ascii_buf\[4\]\[0\] u_parser.u_decoder.ascii_buf\[4\]\[1\]
+ _1268_ u_parser.u_decoder.ascii_buf\[4\]\[2\] VGND VGND VPWR VPWR _1277_ sky130_fd_sc_hd__a31o_1
XFILLER_59_217 VGND VGND VPWR VPWR sky130_fd_sc_hd__decap_6
X_3128_ _0696_ _1564_ _1512_ _1509_ VGND VGND VPWR VPWR _1566_ sky130_fd_sc_hd__o211a_1
XTAP_TAPCELL_ROW_2_224 VGND VPWR sky130_fd_sc_hd__tapvpwrvgnd_1
XFILLER_35_15 VPWR VGND VPWR VGND sky130_ef_sc_hd__decap_12
X_3059_ u_uart_rx.sample_div_count\[2\] _1522_ _1525_ VGND VGND VPWR VPWR _1526_ sky130_fd_sc_hd__o21bai_1
XFILLER_23_331 VGND VGND VPWR VPWR sky130_fd_sc_hd__decap_4
XFILLER_42_139 VGND VGND VPWR VPWR sky130_fd_sc_hd__fill_1
XFILLER_23_342 VPWR VGND VPWR VGND sky130_ef_sc_hd__decap_12
XFILLER_23_375 VGND VGND VPWR VPWR sky130_fd_sc_hd__fill_1
XFILLER_51_69 VPWR VGND VPWR VGND sky130_ef_sc_hd__decap_12
XTAP_TAPCELL_ROW_92_1074 VGND VPWR sky130_fd_sc_hd__tapvpwrvgnd_1
XFILLER_93_529 VGND VGND VPWR VPWR sky130_fd_sc_hd__decap_3
XFILLER_46_401 VGND VGND VPWR VPWR sky130_fd_sc_hd__decap_3
XFILLER_92_65 VGND VGND VPWR VPWR sky130_fd_sc_hd__decap_3
XTAP_TAPCELL_ROW_44_624 VGND VPWR sky130_fd_sc_hd__tapvpwrvgnd_1
XFILLER_41_194 VGND VGND VPWR VPWR sky130_fd_sc_hd__decap_8
X_2430_ u_parser.u_decoder.timeout_count\[6\] _1165_ net3 VGND VGND VPWR VPWR _1166_
+ sky130_fd_sc_hd__o21ai_1
X_2361_ tag_raw\[14\] net442 net15 VGND VGND VPWR VPWR _0287_ sky130_fd_sc_hd__mux2_1
X_2292_ _0682_ _1094_ _1097_ _1098_ VGND VGND VPWR VPWR _1099_ sky130_fd_sc_hd__a22o_1
XFILLER_69_548 VGND VGND VPWR VPWR sky130_fd_sc_hd__decap_6
XFILLER_1_290 VGND VGND VPWR VPWR sky130_fd_sc_hd__decap_6
XFILLER_64_231 VPWR VGND VPWR VGND sky130_ef_sc_hd__decap_12
XFILLER_24_106 VGND VGND VPWR VPWR sky130_fd_sc_hd__decap_3
XFILLER_52_404 VPWR VGND VPWR VGND sky130_ef_sc_hd__decap_12
X_3815_ clknet_leaf_18_clk _0631_ net120 VGND VGND VPWR VPWR u_uart_rx.rx_shift\[0\]
+ sky130_fd_sc_hd__dfrtp_1
X_3746_ clknet_leaf_3_clk net159 VGND VGND VPWR VPWR startup_reset\[1\] sky130_fd_sc_hd__dfxtp_1
XFILLER_9_390 VGND VGND VPWR VPWR sky130_fd_sc_hd__fill_2
X_3677_ clknet_leaf_63_clk _0504_ VGND VGND VPWR VPWR u_tx_fifo.mem\[10\]\[3\] sky130_fd_sc_hd__dfxtp_1
X_2628_ _0686_ u_parser.u_decoder.ascii_buf\[1\]\[5\] _1315_ _1316_ _1311_ VGND VGND
+ VPWR VPWR _1318_ sky130_fd_sc_hd__a311o_1
X_2559_ net450 _1263_ net10 VGND VGND VPWR VPWR _0362_ sky130_fd_sc_hd__mux2_1
XFILLER_87_323 VGND VGND VPWR VPWR sky130_fd_sc_hd__fill_1
XFILLER_87_389 VGND VGND VPWR VPWR sky130_fd_sc_hd__decap_3
XTAP_TAPCELL_ROW_58_749 VGND VPWR sky130_fd_sc_hd__tapvpwrvgnd_1
XFILLER_15_117 VGND VGND VPWR VPWR sky130_fd_sc_hd__fill_1
Xmax_cap48 _1194_ VGND VGND VPWR VPWR net48 sky130_fd_sc_hd__clkbuf_1
XFILLER_43_437 VGND VGND VPWR VPWR sky130_fd_sc_hd__decap_8
XTAP_TAPCELL_ROW_13_329 VGND VPWR sky130_fd_sc_hd__tapvpwrvgnd_1
XFILLER_11_345 VGND VGND VPWR VPWR sky130_fd_sc_hd__decap_3
XFILLER_93_337 VPWR VGND VPWR VGND sky130_ef_sc_hd__decap_12
XFILLER_19_412 VPWR VGND VPWR VGND sky130_ef_sc_hd__decap_12
XFILLER_19_445 VGND VGND VPWR VPWR sky130_fd_sc_hd__decap_3
XTAP_TAPCELL_ROW_29_473 VGND VPWR sky130_fd_sc_hd__tapvpwrvgnd_1
XFILLER_61_234 VGND VGND VPWR VPWR sky130_fd_sc_hd__decap_3
X_1930_ net81 net406 _0874_ VGND VGND VPWR VPWR _0055_ sky130_fd_sc_hd__mux2_1
X_1861_ u_tx_fifo.wr_ptr\[2\] _0889_ VGND VGND VPWR VPWR _0891_ sky130_fd_sc_hd__nand2_1
X_3600_ clknet_leaf_9_clk _0427_ net115 VGND VGND VPWR VPWR u_parser.u_decoder.ascii_buf\[8\]\[3\]
+ sky130_fd_sc_hd__dfrtp_1
X_3531_ clknet_leaf_38_clk _0358_ net127 VGND VGND VPWR VPWR u_parser.u_decoder.decoded_payload\[14\]
+ sky130_fd_sc_hd__dfrtp_1
X_1792_ rx_fifo_in_valid _0847_ VGND VGND VPWR VPWR _0848_ sky130_fd_sc_hd__and2_1
X_3462_ clknet_leaf_45_clk _0289_ net109 VGND VGND VPWR VPWR tag_raw\[16\] sky130_fd_sc_hd__dfrtp_1
X_3393_ clknet_leaf_39_clk _0226_ net99 VGND VGND VPWR VPWR u_parser.u_packet_encoder.tag_latched\[29\]
+ sky130_fd_sc_hd__dfrtp_1
X_2413_ net155 _0793_ VGND VGND VPWR VPWR _1155_ sky130_fd_sc_hd__or2_1
X_2344_ _0677_ u_parser.u_decoder.decoded_checksum_calc\[2\] _0808_ _1137_ VGND VGND
+ VPWR VPWR _1138_ sky130_fd_sc_hd__o211a_1
X_2275_ net434 _1083_ net50 VGND VGND VPWR VPWR _0258_ sky130_fd_sc_hd__mux2_1
XFILLER_69_389 VGND VGND VPWR VPWR sky130_fd_sc_hd__decap_3
XFILLER_92_381 VGND VGND VPWR VPWR sky130_fd_sc_hd__decap_8
XFILLER_12_109 VGND VGND VPWR VPWR sky130_fd_sc_hd__fill_2
XTAP_TAPCELL_ROW_63_796 VGND VPWR sky130_fd_sc_hd__tapvpwrvgnd_1
XFILLER_32_27 VGND VGND VPWR VPWR sky130_fd_sc_hd__fill_1
XFILLER_20_197 VGND VGND VPWR VPWR sky130_fd_sc_hd__decap_3
X_3729_ clknet_leaf_31_clk _0553_ net142 VGND VGND VPWR VPWR u_uart_rx.low_count\[19\]
+ sky130_fd_sc_hd__dfrtp_1
XFILLER_57_57 VGND VGND VPWR VPWR sky130_fd_sc_hd__decap_3
XFILLER_71_554 VGND VGND VPWR VPWR sky130_fd_sc_hd__fill_1
XFILLER_7_146 VGND VGND VPWR VPWR sky130_fd_sc_hd__fill_1
XFILLER_93_101 VGND VGND VPWR VPWR sky130_fd_sc_hd__decap_3
X_2060_ net208 net26 _0960_ VGND VGND VPWR VPWR _0166_ sky130_fd_sc_hd__mux2_1
XFILLER_93_189 VGND VGND VPWR VPWR sky130_fd_sc_hd__decap_6
XFILLER_93_167 VGND VGND VPWR VPWR sky130_fd_sc_hd__fill_1
XFILLER_47_551 VGND VGND VPWR VPWR sky130_fd_sc_hd__fill_1
XFILLER_62_554 VGND VGND VPWR VPWR sky130_fd_sc_hd__fill_1
X_2962_ u_uart_rx.low_count\[9\] _1483_ u_uart_rx.low_count\[10\] VGND VGND VPWR VPWR
+ _1485_ sky130_fd_sc_hd__a21oi_1
X_1913_ net19 net269 _0892_ VGND VGND VPWR VPWR _0043_ sky130_fd_sc_hd__mux2_1
X_2893_ _0661_ u_uart_tx.clk_count\[1\] u_uart_tx.clk_count\[0\] VGND VGND VPWR VPWR
+ _1442_ sky130_fd_sc_hd__and3_1
X_1844_ net326 net77 _0885_ VGND VGND VPWR VPWR _0025_ sky130_fd_sc_hd__mux2_1
X_1775_ _0827_ _0836_ VGND VGND VPWR VPWR _0656_ sky130_fd_sc_hd__nand2_1
X_3514_ clknet_leaf_25_clk _0341_ net136 VGND VGND VPWR VPWR u_parser.u_decoder.timeout_count\[16\]
+ sky130_fd_sc_hd__dfrtp_1
XFILLER_6_190 VGND VGND VPWR VPWR sky130_fd_sc_hd__decap_6
X_3445_ clknet_leaf_38_clk _0008_ net127 VGND VGND VPWR VPWR card_event sky130_fd_sc_hd__dfrtp_1
X_3376_ clknet_leaf_55_clk net478 net98 VGND VGND VPWR VPWR u_parser.u_packet_encoder.tag_latched\[12\]
+ sky130_fd_sc_hd__dfrtp_1
XFILLER_84_101 VGND VGND VPWR VPWR sky130_fd_sc_hd__decap_4
X_2327_ net60 _1127_ u_tx_fifo.rd_ptr\[3\] VGND VGND VPWR VPWR _1130_ sky130_fd_sc_hd__o21a_1
XFILLER_57_326 VGND VGND VPWR VPWR sky130_fd_sc_hd__decap_8
XFILLER_69_186 VGND VGND VPWR VPWR sky130_fd_sc_hd__fill_1
X_2258_ u_tx_fifo.mem\[0\]\[0\] u_tx_fifo.mem\[1\]\[0\] u_tx_fifo.mem\[2\]\[0\] u_tx_fifo.mem\[3\]\[0\]
+ net69 net65 VGND VGND VPWR VPWR _1068_ sky130_fd_sc_hd__mux4_1
XTAP_TAPCELL_ROW_68_844 VGND VPWR sky130_fd_sc_hd__tapvpwrvgnd_1
X_2189_ _1052_ _1060_ VGND VGND VPWR VPWR _1061_ sky130_fd_sc_hd__xnor2_1
XFILLER_43_15 VPWR VGND VPWR VGND sky130_ef_sc_hd__decap_12
XTAP_TAPCELL_ROW_23_424 VGND VPWR sky130_fd_sc_hd__tapvpwrvgnd_1
XFILLER_21_495 VGND VGND VPWR VPWR sky130_fd_sc_hd__decap_8
XFILLER_0_333 VGND VGND VPWR VPWR sky130_fd_sc_hd__decap_3
XFILLER_88_473 VGND VGND VPWR VPWR sky130_fd_sc_hd__decap_3
XFILLER_0_377 VPWR VGND VPWR VGND sky130_ef_sc_hd__decap_12
XTAP_TAPCELL_ROW_89_1046 VGND VPWR sky130_fd_sc_hd__tapvpwrvgnd_1
XFILLER_16_223 VGND VGND VPWR VPWR sky130_fd_sc_hd__fill_1
XFILLER_8_433 VPWR VGND VPWR VGND sky130_ef_sc_hd__decap_12
XFILLER_8_477 VPWR VGND VPWR VGND sky130_ef_sc_hd__decap_12
X_3230_ clknet_leaf_11_clk _0066_ VGND VGND VPWR VPWR u_rx_fifo.mem\[10\]\[5\] sky130_fd_sc_hd__dfxtp_1
X_3161_ net189 net34 _1585_ VGND VGND VPWR VPWR _0642_ sky130_fd_sc_hd__mux2_1
XFILLER_12_3 VGND VGND VPWR VPWR sky130_fd_sc_hd__decap_8
X_2112_ _0981_ _0989_ VGND VGND VPWR VPWR _0990_ sky130_fd_sc_hd__xnor2_4
XFILLER_39_337 VPWR VGND VPWR VGND sky130_ef_sc_hd__decap_12
X_3092_ _1547_ _1548_ VGND VGND VPWR VPWR _0610_ sky130_fd_sc_hd__and2_1
XTAP_TAPCELL_ROW_37_549 VGND VPWR sky130_fd_sc_hd__tapvpwrvgnd_1
X_2043_ net306 net81 _0958_ VGND VGND VPWR VPWR _0151_ sky130_fd_sc_hd__mux2_1
Xfanout19 net20 VGND VGND VPWR VPWR net19 sky130_fd_sc_hd__buf_2
XTAP_TAPCELL_ROW_73_891 VGND VPWR sky130_fd_sc_hd__tapvpwrvgnd_1
X_2945_ u_uart_rx.low_count\[3\] u_uart_rx.low_count\[2\] _1472_ VGND VGND VPWR VPWR
+ _1475_ sky130_fd_sc_hd__and3_1
X_2876_ net292 net31 _1437_ VGND VGND VPWR VPWR _0505_ sky130_fd_sc_hd__mux2_1
X_1827_ u_rx_fifo.wr_ptr\[3\] u_rx_fifo.wr_ptr\[2\] VGND VGND VPWR VPWR _0875_ sky130_fd_sc_hd__nand2_2
Xhold411 u_parser.u_packet_encoder.crc_latched\[5\] VGND VGND VPWR VPWR net567 sky130_fd_sc_hd__dlygate4sd3_1
Xhold400 u_tx_fifo.level\[3\] VGND VGND VPWR VPWR net556 sky130_fd_sc_hd__dlygate4sd3_1
X_1758_ u_uart_rx.vote_ones\[1\] u_uart_rx.state\[3\] _0697_ _0821_ VGND VGND VPWR
+ VPWR _0004_ sky130_fd_sc_hd__a31o_1
Xhold433 u_tx_fifo.level\[0\] VGND VGND VPWR VPWR net589 sky130_fd_sc_hd__dlygate4sd3_1
Xhold444 u_tx_fifo.level\[4\] VGND VGND VPWR VPWR net600 sky130_fd_sc_hd__dlygate4sd3_1
Xhold422 u_parser.u_decoder.ascii_buf\[5\]\[6\] VGND VGND VPWR VPWR net578 sky130_fd_sc_hd__dlygate4sd3_1
Xhold477 _0530_ VGND VGND VPWR VPWR net633 sky130_fd_sc_hd__dlygate4sd3_1
Xhold466 u_uart_tx.clk_count\[1\] VGND VGND VPWR VPWR net622 sky130_fd_sc_hd__dlygate4sd3_1
X_1689_ net58 _0755_ u_rx_fifo.rd_ptr\[3\] VGND VGND VPWR VPWR _0756_ sky130_fd_sc_hd__o21a_1
Xhold455 u_parser.u_decoder.ascii_buf\[11\]\[7\] VGND VGND VPWR VPWR net611 sky130_fd_sc_hd__dlygate4sd3_1
Xhold499 u_uart_rx.sample_div_count\[14\] VGND VGND VPWR VPWR net655 sky130_fd_sc_hd__dlygate4sd3_1
X_3428_ clknet_leaf_60_clk _0261_ net89 VGND VGND VPWR VPWR u_uart_tx.tx_data\[4\]
+ sky130_fd_sc_hd__dfrtp_1
Xhold488 u_parser.u_decoder.ascii_buf\[9\]\[6\] VGND VGND VPWR VPWR net644 sky130_fd_sc_hd__dlygate4sd3_1
X_3359_ clknet_leaf_49_clk _0192_ net102 VGND VGND VPWR VPWR u_parser.u_packet_encoder.crc_latched\[3\]
+ sky130_fd_sc_hd__dfrtp_1
XFILLER_38_15 VPWR VGND VPWR VGND sky130_ef_sc_hd__decap_12
XFILLER_85_443 VGND VGND VPWR VPWR sky130_fd_sc_hd__decap_4
XFILLER_85_454 VGND VGND VPWR VPWR sky130_fd_sc_hd__decap_8
XFILLER_13_215 VGND VGND VPWR VPWR sky130_fd_sc_hd__decap_8
XTAP_TAPCELL_ROW_0_196 VGND VPWR sky130_fd_sc_hd__tapvpwrvgnd_1
XFILLER_5_447 VGND VGND VPWR VPWR sky130_fd_sc_hd__fill_1
XTAP_TAPCELL_ROW_8_274 VGND VPWR sky130_fd_sc_hd__tapvpwrvgnd_1
XFILLER_0_141 VPWR VGND VPWR VGND sky130_ef_sc_hd__decap_12
XFILLER_88_281 VGND VGND VPWR VPWR sky130_fd_sc_hd__fill_1
XFILLER_76_443 VPWR VGND VPWR VGND sky130_ef_sc_hd__decap_12
XFILLER_91_446 VGND VGND VPWR VPWR sky130_fd_sc_hd__fill_2
XFILLER_91_413 VPWR VGND VPWR VGND sky130_ef_sc_hd__decap_12
XFILLER_17_543 VPWR VGND VPWR VGND sky130_ef_sc_hd__decap_12
XFILLER_44_340 VGND VGND VPWR VPWR sky130_fd_sc_hd__decap_3
XFILLER_44_373 VGND VGND VPWR VPWR sky130_fd_sc_hd__decap_4
XFILLER_12_281 VPWR VGND VPWR VGND sky130_ef_sc_hd__decap_12
XTAP_TAPCELL_ROW_42_596 VGND VPWR sky130_fd_sc_hd__tapvpwrvgnd_1
X_2730_ net35 net599 _1375_ VGND VGND VPWR VPWR _0421_ sky130_fd_sc_hd__mux2_1
X_2661_ _1262_ _1320_ VGND VGND VPWR VPWR _1343_ sky130_fd_sc_hd__xor2_1
X_1612_ u_tx_fifo.rd_ptr\[3\] VGND VGND VPWR VPWR _0682_ sky130_fd_sc_hd__inv_2
X_2592_ _1288_ _1289_ VGND VGND VPWR VPWR _1290_ sky130_fd_sc_hd__nor2_1
XFILLER_5_52 VGND VGND VPWR VPWR sky130_fd_sc_hd__decap_4
X_3213_ clknet_leaf_9_clk _0049_ VGND VGND VPWR VPWR u_rx_fifo.mem\[13\]\[4\] sky130_fd_sc_hd__dfxtp_1
XFILLER_79_281 VPWR VGND VPWR VGND sky130_ef_sc_hd__decap_12
X_3144_ u_uart_rx.bit_index\[1\] _0663_ VGND VGND VPWR VPWR _1578_ sky130_fd_sc_hd__nand2_1
XPHY_EDGE_ROW_19_Left_113 VGND VGND VPWR VPWR sky130_fd_sc_hd__decap_3
XFILLER_39_167 VGND VGND VPWR VPWR sky130_fd_sc_hd__fill_1
X_3075_ _1536_ VGND VGND VPWR VPWR _1537_ sky130_fd_sc_hd__inv_2
XFILLER_67_487 VGND VGND VPWR VPWR sky130_fd_sc_hd__fill_1
X_2026_ net218 net33 _0956_ VGND VGND VPWR VPWR _0136_ sky130_fd_sc_hd__mux2_1
XFILLER_50_321 VGND VGND VPWR VPWR sky130_fd_sc_hd__decap_4
XFILLER_50_343 VPWR VGND VPWR VGND sky130_ef_sc_hd__decap_12
XFILLER_10_218 VGND VGND VPWR VPWR sky130_fd_sc_hd__decap_8
X_2928_ net6 _1464_ _1465_ VGND VGND VPWR VPWR _0529_ sky130_fd_sc_hd__and3_1
XPHY_EDGE_ROW_28_Left_122 VGND VGND VPWR VPWR sky130_fd_sc_hd__decap_3
XFILLER_40_27 VGND VGND VPWR VPWR sky130_fd_sc_hd__fill_1
X_2859_ _1433_ _1434_ VGND VGND VPWR VPWR _0491_ sky130_fd_sc_hd__and2_1
Xhold252 u_rx_fifo.mem\[7\]\[3\] VGND VGND VPWR VPWR net408 sky130_fd_sc_hd__dlygate4sd3_1
Xhold241 u_tx_fifo.mem\[9\]\[7\] VGND VGND VPWR VPWR net397 sky130_fd_sc_hd__dlygate4sd3_1
Xhold230 u_tx_fifo.mem\[1\]\[3\] VGND VGND VPWR VPWR net386 sky130_fd_sc_hd__dlygate4sd3_1
Xhold285 u_uart_tx.tx_data\[5\] VGND VGND VPWR VPWR net441 sky130_fd_sc_hd__dlygate4sd3_1
Xhold263 u_parser.u_decoder.decoded_payload\[7\] VGND VGND VPWR VPWR net419 sky130_fd_sc_hd__dlygate4sd3_1
Xhold274 u_parser.u_decoder.decoded_payload\[17\] VGND VGND VPWR VPWR net430 sky130_fd_sc_hd__dlygate4sd3_1
Xhold296 u_parser.u_decoder.decoded_payload\[38\] VGND VGND VPWR VPWR net452 sky130_fd_sc_hd__dlygate4sd3_1
XFILLER_49_69 VPWR VGND VPWR VGND sky130_ef_sc_hd__decap_12
XPHY_EDGE_ROW_37_Left_131 VGND VGND VPWR VPWR sky130_fd_sc_hd__decap_3
XFILLER_58_421 VGND VGND VPWR VPWR sky130_fd_sc_hd__decap_4
XFILLER_58_432 VGND VGND VPWR VPWR sky130_fd_sc_hd__decap_8
XTAP_TAPCELL_ROW_86_1016 VGND VPWR sky130_fd_sc_hd__tapvpwrvgnd_1
XFILLER_65_57 VGND VGND VPWR VPWR sky130_fd_sc_hd__decap_3
XFILLER_73_446 VGND VGND VPWR VPWR sky130_fd_sc_hd__fill_2
XFILLER_73_457 VGND VGND VPWR VPWR sky130_fd_sc_hd__decap_4
XTAP_TAPCELL_ROW_84_997 VGND VPWR sky130_fd_sc_hd__tapvpwrvgnd_1
XFILLER_14_524 VGND VGND VPWR VPWR sky130_fd_sc_hd__decap_8
XPHY_EDGE_ROW_46_Left_140 VGND VGND VPWR VPWR sky130_fd_sc_hd__decap_3
XFILLER_14_83 VGND VGND VPWR VPWR sky130_fd_sc_hd__fill_1
XFILLER_1_461 VPWR VGND VPWR VGND sky130_ef_sc_hd__decap_12
XFILLER_76_251 VGND VGND VPWR VPWR sky130_fd_sc_hd__fill_1
XTAP_TAPCELL_ROW_47_644 VGND VPWR sky130_fd_sc_hd__tapvpwrvgnd_1
XTAP_TAPCELL_ROW_19_379 VGND VPWR sky130_fd_sc_hd__tapvpwrvgnd_1
X_3831_ clknet_leaf_63_clk _0647_ VGND VGND VPWR VPWR u_tx_fifo.mem\[11\]\[0\] sky130_fd_sc_hd__dfxtp_1
XFILLER_32_365 VGND VGND VPWR VPWR sky130_fd_sc_hd__decap_6
XFILLER_20_527 VGND VGND VPWR VPWR sky130_fd_sc_hd__decap_4
X_3762_ clknet_leaf_12_clk _0580_ VGND VGND VPWR VPWR u_rx_fifo.mem\[9\]\[3\] sky130_fd_sc_hd__dfxtp_1
X_3693_ clknet_leaf_60_clk _0517_ net91 VGND VGND VPWR VPWR u_uart_tx.clk_count\[0\]
+ sky130_fd_sc_hd__dfrtp_1
X_2713_ net42 net628 _1373_ VGND VGND VPWR VPWR _0406_ sky130_fd_sc_hd__mux2_1
X_2644_ u_parser.u_decoder.ascii_buf\[0\]\[0\] u_parser.u_decoder.ascii_buf\[0\]\[3\]
+ _1324_ _1330_ VGND VGND VPWR VPWR _1331_ sky130_fd_sc_hd__o31a_1
X_2575_ net432 _1276_ net7 VGND VGND VPWR VPWR _0365_ sky130_fd_sc_hd__mux2_1
XFILLER_87_505 VPWR VGND VPWR VGND sky130_ef_sc_hd__decap_12
X_3127_ _0689_ _1510_ _1513_ VGND VGND VPWR VPWR _1565_ sky130_fd_sc_hd__a21oi_1
XFILLER_82_210 VPWR VGND VPWR VGND sky130_ef_sc_hd__decap_12
XTAP_TAPCELL_ROW_2_225 VGND VPWR sky130_fd_sc_hd__tapvpwrvgnd_1
XFILLER_82_243 VGND VGND VPWR VPWR sky130_fd_sc_hd__decap_8
XFILLER_55_457 VGND VGND VPWR VPWR sky130_fd_sc_hd__decap_8
X_3058_ _0820_ _1511_ VGND VGND VPWR VPWR _1525_ sky130_fd_sc_hd__and2_2
XFILLER_35_27 VPWR VGND VPWR VGND sky130_ef_sc_hd__decap_12
Xclkbuf_leaf_62_clk clknet_3_0__leaf_clk VGND VGND VPWR VPWR clknet_leaf_62_clk sky130_fd_sc_hd__clkbuf_8
XFILLER_35_192 VGND VGND VPWR VPWR sky130_fd_sc_hd__fill_1
X_2009_ net265 net74 _0953_ VGND VGND VPWR VPWR _0122_ sky130_fd_sc_hd__mux2_1
XTAP_TAPCELL_ROW_81_967 VGND VPWR sky130_fd_sc_hd__tapvpwrvgnd_1
XFILLER_11_505 VPWR VGND VPWR VGND sky130_ef_sc_hd__decap_12
XFILLER_23_354 VGND VGND VPWR VPWR sky130_fd_sc_hd__decap_6
XFILLER_51_15 VPWR VGND VPWR VGND sky130_ef_sc_hd__decap_12
XFILLER_2_203 VGND VGND VPWR VPWR sky130_fd_sc_hd__decap_8
XTAP_TAPCELL_ROW_92_1075 VGND VPWR sky130_fd_sc_hd__tapvpwrvgnd_1
XFILLER_18_148 VGND VGND VPWR VPWR sky130_fd_sc_hd__fill_1
XFILLER_14_321 VGND VGND VPWR VPWR sky130_fd_sc_hd__fill_2
XFILLER_61_449 VPWR VGND VPWR VGND sky130_ef_sc_hd__decap_12
XTAP_TAPCELL_ROW_16_349 VGND VPWR sky130_fd_sc_hd__tapvpwrvgnd_1
XFILLER_41_140 VPWR VGND VPWR VGND sky130_ef_sc_hd__decap_12
XTAP_TAPCELL_ROW_52_691 VGND VPWR sky130_fd_sc_hd__tapvpwrvgnd_1
XFILLER_6_553 VGND VGND VPWR VPWR sky130_fd_sc_hd__fill_2
XFILLER_6_531 VGND VGND VPWR VPWR sky130_fd_sc_hd__fill_1
X_2360_ net461 net424 net15 VGND VGND VPWR VPWR _0286_ sky130_fd_sc_hd__mux2_1
XFILLER_69_505 VPWR VGND VPWR VGND sky130_ef_sc_hd__decap_12
X_2291_ net61 _1095_ u_tx_fifo.rd_ptr\[3\] VGND VGND VPWR VPWR _1098_ sky130_fd_sc_hd__o21a_1
XPHY_EDGE_ROW_10_Right_10 VGND VGND VPWR VPWR sky130_fd_sc_hd__decap_3
XFILLER_64_243 VGND VGND VPWR VPWR sky130_fd_sc_hd__decap_8
XFILLER_52_416 VGND VGND VPWR VPWR sky130_fd_sc_hd__decap_4
Xclkbuf_leaf_44_clk clknet_3_3__leaf_clk VGND VGND VPWR VPWR clknet_leaf_44_clk sky130_fd_sc_hd__clkbuf_8
XFILLER_52_427 VGND VGND VPWR VPWR sky130_fd_sc_hd__fill_1
XFILLER_32_173 VGND VGND VPWR VPWR sky130_fd_sc_hd__decap_3
X_3814_ clknet_leaf_18_clk _0010_ net122 VGND VGND VPWR VPWR rx_fifo_in_valid sky130_fd_sc_hd__dfrtp_1
XFILLER_60_493 VGND VGND VPWR VPWR sky130_fd_sc_hd__fill_1
X_3745_ clknet_leaf_3_clk net156 VGND VGND VPWR VPWR startup_reset\[0\] sky130_fd_sc_hd__dfxtp_1
X_3676_ clknet_leaf_65_clk _0503_ VGND VGND VPWR VPWR u_tx_fifo.mem\[10\]\[2\] sky130_fd_sc_hd__dfxtp_1
X_2627_ net420 _1317_ net14 VGND VGND VPWR VPWR _0376_ sky130_fd_sc_hd__mux2_1
X_2558_ u_parser.u_decoder.ascii_buf\[5\]\[2\] _1259_ _1258_ VGND VGND VPWR VPWR _1263_
+ sky130_fd_sc_hd__o21a_1
X_2489_ u_parser.u_decoder.ascii_buf\[8\]\[4\] u_parser.u_decoder.ascii_buf\[8\]\[5\]
+ VGND VGND VPWR VPWR _1208_ sky130_fd_sc_hd__nand2_1
XFILLER_87_357 VGND VGND VPWR VPWR sky130_fd_sc_hd__decap_8
XFILLER_87_346 VGND VGND VPWR VPWR sky130_fd_sc_hd__decap_4
XFILLER_46_15 VPWR VGND VPWR VGND sky130_ef_sc_hd__decap_12
Xclkbuf_leaf_35_clk clknet_3_6__leaf_clk VGND VGND VPWR VPWR clknet_leaf_35_clk sky130_fd_sc_hd__clkbuf_8
XFILLER_23_151 VGND VGND VPWR VPWR sky130_fd_sc_hd__decap_8
XFILLER_11_357 VGND VGND VPWR VPWR sky130_fd_sc_hd__fill_2
XFILLER_11_84 VGND VGND VPWR VPWR sky130_fd_sc_hd__fill_1
XFILLER_87_66 VGND VGND VPWR VPWR sky130_fd_sc_hd__fill_1
XFILLER_93_305 VGND VGND VPWR VPWR sky130_fd_sc_hd__decap_3
XFILLER_93_349 VPWR VGND VPWR VGND sky130_ef_sc_hd__decap_12
XFILLER_19_424 VGND VGND VPWR VPWR sky130_fd_sc_hd__fill_1
XFILLER_19_457 VPWR VGND VPWR VGND sky130_ef_sc_hd__decap_12
XFILLER_19_479 VGND VGND VPWR VPWR sky130_fd_sc_hd__decap_8
XTAP_TAPCELL_ROW_29_474 VGND VPWR sky130_fd_sc_hd__tapvpwrvgnd_1
Xclkbuf_leaf_26_clk clknet_3_7__leaf_clk VGND VGND VPWR VPWR clknet_leaf_26_clk sky130_fd_sc_hd__clkbuf_8
X_1860_ u_tx_fifo.wr_ptr\[3\] u_tx_fifo.wr_ptr\[2\] VGND VGND VPWR VPWR _0890_ sky130_fd_sc_hd__nand2b_2
X_1791_ _0706_ u_rx_fifo.level\[3\] u_rx_fifo.level\[4\] VGND VGND VPWR VPWR _0847_
+ sky130_fd_sc_hd__or3b_1
X_3530_ clknet_leaf_39_clk _0357_ net106 VGND VGND VPWR VPWR u_parser.u_decoder.decoded_payload\[13\]
+ sky130_fd_sc_hd__dfrtp_1
XFILLER_6_372 VPWR VGND VPWR VGND sky130_ef_sc_hd__decap_12
X_3461_ clknet_leaf_39_clk _0288_ net100 VGND VGND VPWR VPWR tag_raw\[15\] sky130_fd_sc_hd__dfrtp_1
X_3392_ clknet_leaf_55_clk _0225_ net99 VGND VGND VPWR VPWR u_parser.u_packet_encoder.tag_latched\[28\]
+ sky130_fd_sc_hd__dfrtp_1
XFILLER_42_3 VPWR VGND VPWR VGND sky130_ef_sc_hd__decap_12
X_2412_ net155 _0793_ VGND VGND VPWR VPWR _1154_ sky130_fd_sc_hd__nor2_1
X_2343_ _0677_ u_parser.u_decoder.decoded_checksum_calc\[2\] u_parser.u_decoder.decoded_checksum_rx\[3\]
+ _0678_ VGND VGND VPWR VPWR _1137_ sky130_fd_sc_hd__a22oi_1
XFILLER_69_335 VGND VGND VPWR VPWR sky130_fd_sc_hd__fill_1
XFILLER_84_305 VGND VGND VPWR VPWR sky130_fd_sc_hd__decap_3
X_2274_ _0682_ _1078_ _1081_ _1082_ VGND VGND VPWR VPWR _1083_ sky130_fd_sc_hd__a22o_1
XFILLER_25_449 VGND VGND VPWR VPWR sky130_fd_sc_hd__decap_8
Xclkbuf_leaf_17_clk clknet_3_5__leaf_clk VGND VGND VPWR VPWR clknet_leaf_17_clk sky130_fd_sc_hd__clkbuf_8
XTAP_TAPCELL_ROW_63_797 VGND VPWR sky130_fd_sc_hd__tapvpwrvgnd_1
X_1989_ net74 net389 _0949_ VGND VGND VPWR VPWR _0106_ sky130_fd_sc_hd__mux2_1
X_3728_ clknet_leaf_30_clk _0552_ net142 VGND VGND VPWR VPWR u_uart_rx.low_count\[18\]
+ sky130_fd_sc_hd__dfrtp_1
X_3659_ clknet_leaf_62_clk _0486_ net90 VGND VGND VPWR VPWR u_tx_fifo.wr_ptr\[1\]
+ sky130_fd_sc_hd__dfrtp_1
XFILLER_75_327 VGND VGND VPWR VPWR sky130_fd_sc_hd__fill_1
XFILLER_56_541 VPWR VGND VPWR VGND sky130_ef_sc_hd__decap_12
XFILLER_75_349 VPWR VGND VPWR VGND sky130_ef_sc_hd__decap_12
XTAP_TAPCELL_ROW_26_444 VGND VPWR sky130_fd_sc_hd__tapvpwrvgnd_1
XFILLER_24_471 VGND VGND VPWR VPWR sky130_fd_sc_hd__decap_4
XFILLER_93_113 VGND VGND VPWR VPWR sky130_fd_sc_hd__decap_6
XFILLER_66_349 VGND VGND VPWR VPWR sky130_fd_sc_hd__decap_6
XFILLER_19_298 VGND VGND VPWR VPWR sky130_fd_sc_hd__decap_8
XFILLER_34_246 VGND VGND VPWR VPWR sky130_fd_sc_hd__decap_6
XFILLER_22_419 VGND VGND VPWR VPWR sky130_fd_sc_hd__fill_1
XFILLER_34_279 VGND VGND VPWR VPWR sky130_fd_sc_hd__fill_1
X_2961_ net654 _1483_ _1484_ VGND VGND VPWR VPWR _0543_ sky130_fd_sc_hd__o21a_1
X_1912_ _0911_ _0933_ _0935_ _0904_ u_parser.u_packet_encoder.crc_latched\[6\] VGND
+ VGND VPWR VPWR _0936_ sky130_fd_sc_hd__o32a_1
X_2892_ u_uart_tx.state\[2\] _1440_ VGND VGND VPWR VPWR _1441_ sky130_fd_sc_hd__or2_1
XTAP_TAPCELL_ROW_60_767 VGND VPWR sky130_fd_sc_hd__tapvpwrvgnd_1
X_1843_ net414 net78 _0885_ VGND VGND VPWR VPWR _0024_ sky130_fd_sc_hd__mux2_1
X_1774_ _0835_ _0826_ _0825_ VGND VGND VPWR VPWR _0836_ sky130_fd_sc_hd__mux2_1
X_3513_ clknet_leaf_25_clk _0340_ net136 VGND VGND VPWR VPWR u_parser.u_decoder.timeout_count\[15\]
+ sky130_fd_sc_hd__dfrtp_1
X_3444_ clknet_leaf_18_clk _0007_ net123 VGND VGND VPWR VPWR u_uart_rx.state\[4\]
+ sky130_fd_sc_hd__dfrtp_1
Xclkbuf_leaf_6_clk clknet_3_1__leaf_clk VGND VGND VPWR VPWR clknet_leaf_6_clk sky130_fd_sc_hd__clkbuf_8
X_3375_ clknet_leaf_42_clk _0208_ net108 VGND VGND VPWR VPWR u_parser.u_packet_encoder.tag_latched\[11\]
+ sky130_fd_sc_hd__dfrtp_1
X_2326_ _0681_ _1128_ VGND VGND VPWR VPWR _1129_ sky130_fd_sc_hd__or2_1
XFILLER_69_165 VGND VGND VPWR VPWR sky130_fd_sc_hd__decap_3
XTAP_TAPCELL_ROW_68_845 VGND VPWR sky130_fd_sc_hd__tapvpwrvgnd_1
X_2257_ net71 net318 _0876_ VGND VGND VPWR VPWR _0256_ sky130_fd_sc_hd__mux2_1
X_2188_ _1026_ _1056_ VGND VGND VPWR VPWR _1060_ sky130_fd_sc_hd__xnor2_1
XFILLER_53_544 VGND VGND VPWR VPWR sky130_fd_sc_hd__decap_8
XFILLER_43_27 VPWR VGND VPWR VGND sky130_ef_sc_hd__decap_12
XFILLER_4_139 VGND VGND VPWR VPWR sky130_fd_sc_hd__fill_1
XFILLER_0_389 VGND VGND VPWR VPWR sky130_fd_sc_hd__decap_3
XTAP_TAPCELL_ROW_89_1047 VGND VPWR sky130_fd_sc_hd__tapvpwrvgnd_1
XFILLER_56_360 VGND VGND VPWR VPWR sky130_fd_sc_hd__decap_4
XFILLER_44_544 VGND VGND VPWR VPWR sky130_fd_sc_hd__decap_8
XFILLER_24_290 VGND VGND VPWR VPWR sky130_fd_sc_hd__decap_4
XFILLER_31_249 VGND VGND VPWR VPWR sky130_fd_sc_hd__fill_1
XFILLER_8_401 VPWR VGND VPWR VGND sky130_ef_sc_hd__decap_12
XFILLER_8_445 VPWR VGND VPWR VGND sky130_ef_sc_hd__decap_12
XFILLER_8_489 VPWR VGND VPWR VGND sky130_ef_sc_hd__decap_12
X_3160_ net206 net24 _1585_ VGND VGND VPWR VPWR _0641_ sky130_fd_sc_hd__mux2_1
XFILLER_39_316 VGND VGND VPWR VPWR sky130_fd_sc_hd__fill_1
X_3091_ u_uart_rx.sample_div_count\[11\] _1543_ u_uart_rx.sample_div_count\[12\] VGND
+ VGND VPWR VPWR _1548_ sky130_fd_sc_hd__a21o_1
X_2111_ tag_raw\[37\] tag_raw\[31\] VGND VGND VPWR VPWR _0989_ sky130_fd_sc_hd__xor2_2
XFILLER_39_349 VPWR VGND VPWR VGND sky130_ef_sc_hd__decap_12
Xhold1 rst_n VGND VGND VPWR VPWR net157 sky130_fd_sc_hd__dlygate4sd3_1
X_2042_ net272 net82 _0958_ VGND VGND VPWR VPWR _0150_ sky130_fd_sc_hd__mux2_1
XTAP_TAPCELL_ROW_65_815 VGND VPWR sky130_fd_sc_hd__tapvpwrvgnd_1
XFILLER_81_138 VGND VGND VPWR VPWR sky130_fd_sc_hd__decap_4
XFILLER_81_105 VGND VGND VPWR VPWR sky130_fd_sc_hd__decap_6
XFILLER_35_511 VPWR VGND VPWR VGND sky130_ef_sc_hd__decap_12
XPHY_EDGE_ROW_8_Right_8 VGND VGND VPWR VPWR sky130_fd_sc_hd__decap_3
XFILLER_62_385 VGND VGND VPWR VPWR sky130_fd_sc_hd__decap_6
XTAP_TAPCELL_ROW_73_892 VGND VPWR sky130_fd_sc_hd__tapvpwrvgnd_1
X_2944_ u_uart_rx.low_count\[2\] _1472_ u_uart_rx.low_count\[3\] VGND VGND VPWR VPWR
+ _1474_ sky130_fd_sc_hd__a21oi_1
X_2875_ net324 net34 _1437_ VGND VGND VPWR VPWR _0504_ sky130_fd_sc_hd__mux2_1
XFILLER_30_293 VGND VGND VPWR VPWR sky130_fd_sc_hd__decap_4
X_1826_ u_rx_fifo.wr_ptr\[3\] _0871_ VGND VGND VPWR VPWR _0874_ sky130_fd_sc_hd__nand2b_4
Xhold401 u_parser.u_decoder.ascii_buf\[2\]\[6\] VGND VGND VPWR VPWR net557 sky130_fd_sc_hd__dlygate4sd3_1
Xhold445 u_uart_rx.sample_div_count\[10\] VGND VGND VPWR VPWR net601 sky130_fd_sc_hd__dlygate4sd3_1
X_1757_ rdm_rx_sync u_uart_rx.state\[0\] net620 u_uart_rx.break_detect VGND VGND VPWR
+ VPWR _0821_ sky130_fd_sc_hd__a211o_1
Xhold434 u_parser.u_decoder.ascii_buf\[4\]\[5\] VGND VGND VPWR VPWR net590 sky130_fd_sc_hd__dlygate4sd3_1
Xhold412 u_parser.u_decoder.ascii_buf\[1\]\[5\] VGND VGND VPWR VPWR net568 sky130_fd_sc_hd__dlygate4sd3_1
Xhold423 u_parser.u_decoder.ascii_buf\[6\]\[5\] VGND VGND VPWR VPWR net579 sky130_fd_sc_hd__dlygate4sd3_1
Xhold456 u_parser.u_decoder.timeout_count\[8\] VGND VGND VPWR VPWR net612 sky130_fd_sc_hd__dlygate4sd3_1
Xhold467 u_parser.u_decoder.timeout_count\[0\] VGND VGND VPWR VPWR net623 sky130_fd_sc_hd__dlygate4sd3_1
Xhold478 u_uart_tx.clk_count\[5\] VGND VGND VPWR VPWR net634 sky130_fd_sc_hd__dlygate4sd3_1
X_1688_ u_rx_fifo.mem\[12\]\[1\] u_rx_fifo.mem\[13\]\[1\] u_rx_fifo.mem\[14\]\[1\]
+ u_rx_fifo.mem\[15\]\[1\] net152 net148 VGND VGND VPWR VPWR _0755_ sky130_fd_sc_hd__mux4_1
Xhold489 parser_tx_valid VGND VGND VPWR VPWR net645 sky130_fd_sc_hd__dlygate4sd3_1
X_3427_ clknet_leaf_61_clk _0260_ net88 VGND VGND VPWR VPWR u_uart_tx.tx_data\[3\]
+ sky130_fd_sc_hd__dfrtp_1
XPHY_EDGE_ROW_39_Right_39 VGND VGND VPWR VPWR sky130_fd_sc_hd__decap_3
X_3358_ clknet_leaf_49_clk _0191_ net102 VGND VGND VPWR VPWR u_parser.u_packet_encoder.crc_latched\[2\]
+ sky130_fd_sc_hd__dfrtp_1
XFILLER_38_27 VGND VGND VPWR VPWR sky130_fd_sc_hd__fill_1
X_2309_ net60 _1111_ u_tx_fifo.rd_ptr\[3\] VGND VGND VPWR VPWR _1114_ sky130_fd_sc_hd__o21a_1
XFILLER_38_49 VGND VGND VPWR VPWR sky130_fd_sc_hd__fill_1
X_3289_ clknet_leaf_5_clk _0125_ VGND VGND VPWR VPWR u_tx_fifo.mem\[5\]\[0\] sky130_fd_sc_hd__dfxtp_1
XFILLER_57_157 VGND VGND VPWR VPWR sky130_fd_sc_hd__decap_3
XFILLER_45_319 VGND VGND VPWR VPWR sky130_fd_sc_hd__decap_6
XFILLER_26_533 VPWR VGND VPWR VGND sky130_ef_sc_hd__decap_12
XFILLER_54_15 VPWR VGND VPWR VGND sky130_ef_sc_hd__decap_12
XFILLER_72_138 VGND VGND VPWR VPWR sky130_fd_sc_hd__fill_2
XTAP_TAPCELL_ROW_0_197 VGND VPWR sky130_fd_sc_hd__tapvpwrvgnd_1
XFILLER_41_547 VGND VGND VPWR VPWR sky130_fd_sc_hd__decap_8
XPHY_EDGE_ROW_48_Right_48 VGND VGND VPWR VPWR sky130_fd_sc_hd__decap_3
XFILLER_70_69 VGND VGND VPWR VPWR sky130_fd_sc_hd__fill_1
XPHY_EDGE_ROW_57_Right_57 VGND VGND VPWR VPWR sky130_fd_sc_hd__decap_3
XTAP_TAPCELL_ROW_8_275 VGND VPWR sky130_fd_sc_hd__tapvpwrvgnd_1
XFILLER_0_153 VPWR VGND VPWR VGND sky130_ef_sc_hd__decap_12
XFILLER_0_197 VPWR VGND VPWR VGND sky130_ef_sc_hd__decap_12
XFILLER_76_477 VPWR VGND VPWR VGND sky130_ef_sc_hd__decap_12
XFILLER_76_455 VGND VGND VPWR VPWR sky130_fd_sc_hd__decap_8
XFILLER_91_425 VGND VGND VPWR VPWR sky130_fd_sc_hd__fill_1
XFILLER_36_319 VGND VGND VPWR VPWR sky130_fd_sc_hd__fill_2
XFILLER_29_393 VPWR VGND VPWR VGND sky130_ef_sc_hd__decap_12
XPHY_EDGE_ROW_66_Right_66 VGND VGND VPWR VPWR sky130_fd_sc_hd__decap_3
XTAP_TAPCELL_ROW_70_862 VGND VPWR sky130_fd_sc_hd__tapvpwrvgnd_1
XFILLER_12_271 VGND VGND VPWR VPWR sky130_fd_sc_hd__decap_4
XTAP_TAPCELL_ROW_42_597 VGND VPWR sky130_fd_sc_hd__tapvpwrvgnd_1
X_2660_ net560 _1342_ net13 VGND VGND VPWR VPWR _0384_ sky130_fd_sc_hd__mux2_1
X_1611_ net60 VGND VGND VPWR VPWR _0681_ sky130_fd_sc_hd__inv_2
XPHY_EDGE_ROW_75_Right_75 VGND VGND VPWR VPWR sky130_fd_sc_hd__decap_3
X_2591_ _0684_ _1282_ u_parser.u_decoder.ascii_buf\[3\]\[1\] VGND VGND VPWR VPWR _1289_
+ sky130_fd_sc_hd__o21ba_1
X_3212_ clknet_leaf_21_clk _0048_ VGND VGND VPWR VPWR u_rx_fifo.mem\[13\]\[3\] sky130_fd_sc_hd__dfxtp_1
XFILLER_79_293 VGND VGND VPWR VPWR sky130_fd_sc_hd__fill_2
XFILLER_39_113 VGND VGND VPWR VPWR sky130_fd_sc_hd__decap_3
X_3143_ u_uart_rx.bit_index\[1\] _0663_ VGND VGND VPWR VPWR _1577_ sky130_fd_sc_hd__and2_1
XTAP_TAPCELL_ROW_78_940 VGND VPWR sky130_fd_sc_hd__tapvpwrvgnd_1
X_3074_ u_uart_rx.sample_div_count\[7\] _1534_ VGND VGND VPWR VPWR _1536_ sky130_fd_sc_hd__and2_1
XPHY_EDGE_ROW_84_Right_84 VGND VGND VPWR VPWR sky130_fd_sc_hd__decap_3
X_2025_ net405 net23 _0956_ VGND VGND VPWR VPWR _0135_ sky130_fd_sc_hd__mux2_1
XFILLER_35_363 VGND VGND VPWR VPWR sky130_fd_sc_hd__fill_1
XFILLER_23_525 VPWR VGND VPWR VGND sky130_ef_sc_hd__decap_12
XFILLER_24_29 VGND VGND VPWR VPWR sky130_fd_sc_hd__decap_3
XFILLER_62_193 VGND VGND VPWR VPWR sky130_fd_sc_hd__decap_3
X_2927_ u_uart_tx.clk_count\[12\] _1462_ VGND VGND VPWR VPWR _1465_ sky130_fd_sc_hd__nand2_1
XPHY_EDGE_ROW_93_Right_93 VGND VGND VPWR VPWR sky130_fd_sc_hd__decap_3
X_2858_ net146 _1431_ VGND VGND VPWR VPWR _1434_ sky130_fd_sc_hd__or2_1
Xhold220 u_rx_fifo.mem\[0\]\[7\] VGND VGND VPWR VPWR net376 sky130_fd_sc_hd__dlygate4sd3_1
X_2789_ _0813_ _1407_ net570 VGND VGND VPWR VPWR _0447_ sky130_fd_sc_hd__o21a_1
X_1809_ _0659_ _0797_ _0849_ _0855_ _0861_ VGND VGND VPWR VPWR _0862_ sky130_fd_sc_hd__o41a_1
Xhold242 u_rx_fifo.mem\[1\]\[4\] VGND VGND VPWR VPWR net398 sky130_fd_sc_hd__dlygate4sd3_1
Xhold253 u_rx_fifo.mem\[1\]\[6\] VGND VGND VPWR VPWR net409 sky130_fd_sc_hd__dlygate4sd3_1
Xhold231 u_rx_fifo.mem\[5\]\[2\] VGND VGND VPWR VPWR net387 sky130_fd_sc_hd__dlygate4sd3_1
Xhold275 u_parser.u_packet_encoder.tag_latched\[13\] VGND VGND VPWR VPWR net431 sky130_fd_sc_hd__dlygate4sd3_1
Xhold264 u_parser.u_decoder.decoded_payload\[32\] VGND VGND VPWR VPWR net420 sky130_fd_sc_hd__dlygate4sd3_1
Xhold286 u_parser.u_decoder.decoded_payload\[14\] VGND VGND VPWR VPWR net442 sky130_fd_sc_hd__dlygate4sd3_1
XFILLER_49_15 VPWR VGND VPWR VGND sky130_ef_sc_hd__decap_12
Xhold297 u_parser.u_decoder.decoded_payload\[9\] VGND VGND VPWR VPWR net453 sky130_fd_sc_hd__dlygate4sd3_1
XTAP_TAPCELL_ROW_5_245 VGND VPWR sky130_fd_sc_hd__tapvpwrvgnd_1
XFILLER_85_241 VGND VGND VPWR VPWR sky130_fd_sc_hd__decap_3
XTAP_TAPCELL_ROW_86_1017 VGND VPWR sky130_fd_sc_hd__tapvpwrvgnd_1
XFILLER_45_105 VGND VGND VPWR VPWR sky130_fd_sc_hd__decap_6
XFILLER_58_477 VGND VGND VPWR VPWR sky130_fd_sc_hd__fill_2
XTAP_TAPCELL_ROW_84_998 VGND VPWR sky130_fd_sc_hd__tapvpwrvgnd_1
XFILLER_26_352 VPWR VGND VPWR VGND sky130_ef_sc_hd__decap_12
XFILLER_5_223 VGND VGND VPWR VPWR sky130_fd_sc_hd__fill_1
XFILLER_5_289 VGND VGND VPWR VPWR sky130_fd_sc_hd__decap_6
XFILLER_5_267 VPWR VGND VPWR VGND sky130_ef_sc_hd__decap_12
XFILLER_30_61 VGND VGND VPWR VPWR sky130_fd_sc_hd__decap_4
XFILLER_30_83 VGND VGND VPWR VPWR sky130_fd_sc_hd__fill_1
XFILLER_1_473 VPWR VGND VPWR VGND sky130_ef_sc_hd__decap_12
XTAP_TAPCELL_ROW_75_910 VGND VPWR sky130_fd_sc_hd__tapvpwrvgnd_1
XFILLER_36_138 VGND VGND VPWR VPWR sky130_fd_sc_hd__fill_2
XTAP_TAPCELL_ROW_47_645 VGND VPWR sky130_fd_sc_hd__tapvpwrvgnd_1
X_3830_ clknet_leaf_6_clk _0646_ VGND VGND VPWR VPWR u_tx_fifo.mem\[0\]\[7\] sky130_fd_sc_hd__dfxtp_1
X_3761_ clknet_leaf_11_clk _0579_ VGND VGND VPWR VPWR u_rx_fifo.mem\[9\]\[2\] sky130_fd_sc_hd__dfxtp_1
X_2712_ _0779_ net591 _1373_ VGND VGND VPWR VPWR _0405_ sky130_fd_sc_hd__mux2_1
X_3692_ clknet_leaf_60_clk _0657_ net91 VGND VGND VPWR VPWR u_uart_tx.state\[2\] sky130_fd_sc_hd__dfrtp_1
XFILLER_72_3 VPWR VGND VPWR VGND sky130_ef_sc_hd__decap_12
X_2643_ u_parser.u_decoder.ascii_buf\[0\]\[0\] u_parser.u_decoder.ascii_buf\[0\]\[1\]
+ u_parser.u_decoder.ascii_buf\[0\]\[2\] _1329_ VGND VGND VPWR VPWR _1330_ sky130_fd_sc_hd__a31oi_1
X_2574_ _1274_ _1275_ VGND VGND VPWR VPWR _1276_ sky130_fd_sc_hd__and2_1
XFILLER_87_517 VPWR VGND VPWR VGND sky130_ef_sc_hd__decap_12
X_3126_ u_uart_rx.sample_phase\[4\] rdm_rx_sync _1518_ _1563_ VGND VGND VPWR VPWR
+ _1564_ sky130_fd_sc_hd__and4b_1
XFILLER_82_222 VGND VGND VPWR VPWR sky130_fd_sc_hd__fill_1
X_3057_ _1513_ _1523_ _1524_ VGND VGND VPWR VPWR _0599_ sky130_fd_sc_hd__and3_1
XFILLER_35_39 VGND VGND VPWR VPWR sky130_fd_sc_hd__decap_4
X_2008_ net256 net76 _0953_ VGND VGND VPWR VPWR _0121_ sky130_fd_sc_hd__mux2_1
XTAP_TAPCELL_ROW_81_968 VGND VPWR sky130_fd_sc_hd__tapvpwrvgnd_1
XFILLER_50_141 VGND VGND VPWR VPWR sky130_fd_sc_hd__decap_4
XFILLER_11_517 VPWR VGND VPWR VGND sky130_ef_sc_hd__decap_12
XFILLER_51_27 VPWR VGND VPWR VGND sky130_ef_sc_hd__decap_12
XTAP_TAPCELL_ROW_92_1076 VGND VPWR sky130_fd_sc_hd__tapvpwrvgnd_1
X_3745__156 VGND VGND VPWR VPWR net156 _3745__156/LO sky130_fd_sc_hd__conb_1
XTAP_TAPCELL_ROW_44_615 VGND VPWR sky130_fd_sc_hd__tapvpwrvgnd_1
XFILLER_41_130 VGND VGND VPWR VPWR sky130_fd_sc_hd__fill_1
XFILLER_14_388 VGND VGND VPWR VPWR sky130_fd_sc_hd__fill_1
XFILLER_41_152 VPWR VGND VPWR VGND sky130_ef_sc_hd__decap_12
XTAP_TAPCELL_ROW_52_692 VGND VPWR sky130_fd_sc_hd__tapvpwrvgnd_1
XFILLER_69_517 VGND VGND VPWR VPWR sky130_fd_sc_hd__fill_2
X_2290_ _0681_ _1096_ VGND VGND VPWR VPWR _1097_ sky130_fd_sc_hd__or2_1
XFILLER_92_531 VGND VGND VPWR VPWR sky130_fd_sc_hd__fill_1
XFILLER_37_447 VGND VGND VPWR VPWR sky130_fd_sc_hd__fill_1
XFILLER_37_458 VGND VGND VPWR VPWR sky130_fd_sc_hd__decap_6
XFILLER_92_553 VGND VGND VPWR VPWR sky130_fd_sc_hd__fill_2
X_3813_ clknet_leaf_27_clk _0630_ net124 VGND VGND VPWR VPWR u_uart_rx.vote_ones\[1\]
+ sky130_fd_sc_hd__dfrtp_2
XFILLER_9_370 VPWR VGND VPWR VGND sky130_ef_sc_hd__decap_12
X_3744_ clknet_leaf_63_clk _0568_ VGND VGND VPWR VPWR u_tx_fifo.mem\[8\]\[7\] sky130_fd_sc_hd__dfxtp_1
XFILLER_20_369 VGND VGND VPWR VPWR sky130_fd_sc_hd__fill_1
X_3675_ clknet_leaf_62_clk _0502_ VGND VGND VPWR VPWR u_tx_fifo.mem\[10\]\[1\] sky130_fd_sc_hd__dfxtp_1
X_2626_ u_parser.u_decoder.ascii_buf\[1\]\[0\] _1316_ _1312_ VGND VGND VPWR VPWR _1317_
+ sky130_fd_sc_hd__o21a_1
XPHY_EDGE_ROW_65_Left_159 VGND VGND VPWR VPWR sky130_fd_sc_hd__decap_3
X_2557_ net430 _1262_ net10 VGND VGND VPWR VPWR _0361_ sky130_fd_sc_hd__mux2_1
X_2488_ u_parser.u_decoder.ascii_buf\[8\]\[1\] u_parser.u_decoder.ascii_buf\[8\]\[2\]
+ VGND VGND VPWR VPWR _1207_ sky130_fd_sc_hd__or2_1
XFILLER_83_531 VPWR VGND VPWR VGND sky130_ef_sc_hd__decap_12
XFILLER_46_27 VGND VGND VPWR VPWR sky130_fd_sc_hd__fill_1
XPHY_EDGE_ROW_74_Left_168 VGND VGND VPWR VPWR sky130_fd_sc_hd__decap_3
X_3109_ net509 net85 _0845_ VGND VGND VPWR VPWR _0617_ sky130_fd_sc_hd__mux2_1
XFILLER_15_108 VGND VGND VPWR VPWR sky130_fd_sc_hd__decap_4
XFILLER_70_214 VGND VGND VPWR VPWR sky130_fd_sc_hd__fill_1
XFILLER_62_15 VPWR VGND VPWR VGND sky130_ef_sc_hd__decap_12
XFILLER_51_461 VGND VGND VPWR VPWR sky130_fd_sc_hd__fill_1
XPHY_EDGE_ROW_83_Left_177 VGND VGND VPWR VPWR sky130_fd_sc_hd__decap_3
XTAP_TAPCELL_ROW_21_397 VGND VPWR sky130_fd_sc_hd__tapvpwrvgnd_1
XFILLER_2_3 VPWR VGND VPWR VGND sky130_ef_sc_hd__decap_12
XPHY_EDGE_ROW_92_Left_186 VGND VGND VPWR VPWR sky130_fd_sc_hd__decap_3
XFILLER_74_520 VPWR VGND VPWR VGND sky130_ef_sc_hd__decap_12
XFILLER_19_469 VGND VGND VPWR VPWR sky130_fd_sc_hd__fill_1
XTAP_TAPCELL_ROW_57_740 VGND VPWR sky130_fd_sc_hd__tapvpwrvgnd_1
XFILLER_74_553 VGND VGND VPWR VPWR sky130_fd_sc_hd__fill_2
XTAP_TAPCELL_ROW_29_475 VGND VPWR sky130_fd_sc_hd__tapvpwrvgnd_1
XPHY_EDGE_ROW_1_Left_95 VGND VGND VPWR VPWR sky130_fd_sc_hd__decap_3
XTAP_TAPCELL_ROW_12_320 VGND VPWR sky130_fd_sc_hd__tapvpwrvgnd_1
X_1790_ _0846_ VGND VGND VPWR VPWR _0000_ sky130_fd_sc_hd__inv_2
XFILLER_6_362 VGND VGND VPWR VPWR sky130_fd_sc_hd__fill_2
XFILLER_6_340 VGND VGND VPWR VPWR sky130_fd_sc_hd__fill_1
XFILLER_6_384 VPWR VGND VPWR VGND sky130_ef_sc_hd__decap_12
X_3460_ clknet_leaf_40_clk _0287_ net106 VGND VGND VPWR VPWR tag_raw\[14\] sky130_fd_sc_hd__dfrtp_1
X_2411_ u_parser.u_decoder.timeout_count\[0\] _1152_ VGND VGND VPWR VPWR _1153_ sky130_fd_sc_hd__and2_1
X_3391_ clknet_leaf_41_clk _0224_ net106 VGND VGND VPWR VPWR u_parser.u_packet_encoder.tag_latched\[27\]
+ sky130_fd_sc_hd__dfrtp_1
XFILLER_35_3 VPWR VGND VPWR VGND sky130_ef_sc_hd__decap_12
X_2342_ u_parser.u_decoder.decoded_checksum_rx\[4\] _0680_ _0802_ _1135_ VGND VGND
+ VPWR VPWR _1136_ sky130_fd_sc_hd__o211a_1
XFILLER_69_369 VGND VGND VPWR VPWR sky130_fd_sc_hd__decap_3
XFILLER_84_317 VPWR VGND VPWR VGND sky130_ef_sc_hd__decap_12
X_2273_ net60 _1079_ u_tx_fifo.rd_ptr\[3\] VGND VGND VPWR VPWR _1082_ sky130_fd_sc_hd__o21a_1
XFILLER_37_222 VGND VGND VPWR VPWR sky130_fd_sc_hd__fill_2
XFILLER_65_531 VPWR VGND VPWR VGND sky130_ef_sc_hd__decap_12
XFILLER_25_406 VPWR VGND VPWR VGND sky130_ef_sc_hd__decap_12
XTAP_TAPCELL_ROW_63_798 VGND VPWR sky130_fd_sc_hd__tapvpwrvgnd_1
XFILLER_32_29 VGND VGND VPWR VPWR sky130_fd_sc_hd__decap_4
XFILLER_60_291 VPWR VGND VPWR VGND sky130_ef_sc_hd__decap_12
X_3727_ clknet_leaf_30_clk _0551_ net139 VGND VGND VPWR VPWR u_uart_rx.low_count\[17\]
+ sky130_fd_sc_hd__dfrtp_1
X_1988_ net76 net281 _0949_ VGND VGND VPWR VPWR _0105_ sky130_fd_sc_hd__mux2_1
X_3658_ clknet_leaf_58_clk _0485_ net90 VGND VGND VPWR VPWR u_tx_fifo.wr_ptr\[0\]
+ sky130_fd_sc_hd__dfrtp_1
X_3589_ clknet_leaf_44_clk _0416_ net111 VGND VGND VPWR VPWR u_parser.u_decoder.ascii_buf\[9\]\[0\]
+ sky130_fd_sc_hd__dfrtp_1
X_2609_ _0685_ _1296_ u_parser.u_decoder.ascii_buf\[2\]\[1\] VGND VGND VPWR VPWR _1303_
+ sky130_fd_sc_hd__o21ba_1
XFILLER_0_505 VPWR VGND VPWR VGND sky130_ef_sc_hd__decap_12
XFILLER_48_509 VPWR VGND VPWR VGND sky130_ef_sc_hd__decap_12
XFILLER_57_15 VPWR VGND VPWR VGND sky130_ef_sc_hd__decap_12
XFILLER_87_177 VGND VGND VPWR VPWR sky130_fd_sc_hd__fill_2
XFILLER_28_222 VGND VGND VPWR VPWR sky130_fd_sc_hd__decap_8
XFILLER_90_309 VPWR VGND VPWR VGND sky130_ef_sc_hd__decap_12
XFILLER_28_266 VGND VGND VPWR VPWR sky130_fd_sc_hd__fill_1
XFILLER_56_553 VGND VGND VPWR VPWR sky130_fd_sc_hd__fill_2
XTAP_TAPCELL_ROW_54_710 VGND VPWR sky130_fd_sc_hd__tapvpwrvgnd_1
XTAP_TAPCELL_ROW_26_445 VGND VPWR sky130_fd_sc_hd__tapvpwrvgnd_1
XFILLER_22_40 VGND VGND VPWR VPWR sky130_fd_sc_hd__fill_1
XFILLER_22_73 VGND VGND VPWR VPWR sky130_fd_sc_hd__decap_4
XFILLER_93_136 VGND VGND VPWR VPWR sky130_fd_sc_hd__decap_4
XFILLER_47_81 VPWR VGND VPWR VGND sky130_ef_sc_hd__decap_12
XFILLER_34_214 VGND VGND VPWR VPWR sky130_fd_sc_hd__decap_3
XFILLER_74_361 VGND VGND VPWR VPWR sky130_fd_sc_hd__decap_3
X_2960_ u_uart_rx.low_count\[9\] _1483_ net86 VGND VGND VPWR VPWR _1484_ sky130_fd_sc_hd__a21oi_1
X_2891_ net582 _1440_ _1439_ VGND VGND VPWR VPWR _0517_ sky130_fd_sc_hd__o21ba_1
X_1911_ u_parser.u_packet_encoder.tag_latched\[30\] _0900_ _0902_ u_parser.u_packet_encoder.tag_latched\[6\]
+ _0934_ VGND VGND VPWR VPWR _0935_ sky130_fd_sc_hd__a221o_1
XTAP_TAPCELL_ROW_60_768 VGND VPWR sky130_fd_sc_hd__tapvpwrvgnd_1
X_1842_ net366 net81 _0885_ VGND VGND VPWR VPWR _0023_ sky130_fd_sc_hd__mux2_1
X_1773_ u_uart_tx.state\[2\] u_uart_tx.state\[1\] u_uart_tx.state\[0\] VGND VGND VPWR
+ VPWR _0835_ sky130_fd_sc_hd__or3b_1
X_3512_ clknet_leaf_28_clk _0339_ net136 VGND VGND VPWR VPWR u_parser.u_decoder.timeout_count\[14\]
+ sky130_fd_sc_hd__dfrtp_1
X_3443_ clknet_leaf_26_clk _0006_ net124 VGND VGND VPWR VPWR u_uart_rx.state\[3\]
+ sky130_fd_sc_hd__dfrtp_1
X_3374_ clknet_leaf_48_clk _0207_ net103 VGND VGND VPWR VPWR u_parser.u_packet_encoder.tag_latched\[10\]
+ sky130_fd_sc_hd__dfrtp_1
XFILLER_69_111 VGND VGND VPWR VPWR sky130_fd_sc_hd__fill_1
X_2325_ u_tx_fifo.mem\[12\]\[7\] u_tx_fifo.mem\[13\]\[7\] u_tx_fifo.mem\[14\]\[7\]
+ u_tx_fifo.mem\[15\]\[7\] net66 net62 VGND VGND VPWR VPWR _1128_ sky130_fd_sc_hd__mux4_1
XFILLER_38_531 VGND VGND VPWR VPWR sky130_fd_sc_hd__fill_1
X_2256_ net73 net411 _0876_ VGND VGND VPWR VPWR _0255_ sky130_fd_sc_hd__mux2_1
XTAP_TAPCELL_ROW_68_846 VGND VPWR sky130_fd_sc_hd__tapvpwrvgnd_1
XFILLER_38_553 VGND VGND VPWR VPWR sky130_fd_sc_hd__fill_2
X_2187_ net567 net52 _1058_ _1059_ VGND VGND VPWR VPWR _0194_ sky130_fd_sc_hd__a22o_1
XFILLER_65_372 VPWR VGND VPWR VGND sky130_ef_sc_hd__decap_12
XFILLER_43_39 VPWR VGND VPWR VGND sky130_ef_sc_hd__decap_12
XTAP_TAPCELL_ROW_31_492 VGND VPWR sky130_fd_sc_hd__tapvpwrvgnd_1
XFILLER_88_486 VPWR VGND VPWR VGND sky130_ef_sc_hd__decap_12
XFILLER_48_317 VGND VGND VPWR VPWR sky130_fd_sc_hd__decap_4
XFILLER_48_339 VGND VGND VPWR VPWR sky130_fd_sc_hd__fill_2
XTAP_TAPCELL_ROW_89_1048 VGND VPWR sky130_fd_sc_hd__tapvpwrvgnd_1
XFILLER_63_309 VGND VGND VPWR VPWR sky130_fd_sc_hd__fill_1
XFILLER_75_169 VGND VGND VPWR VPWR sky130_fd_sc_hd__decap_4
XTAP_TAPCELL_ROW_39_570 VGND VPWR sky130_fd_sc_hd__tapvpwrvgnd_1
XFILLER_44_501 VGND VGND VPWR VPWR sky130_fd_sc_hd__fill_2
XFILLER_44_512 VGND VGND VPWR VPWR sky130_fd_sc_hd__decap_8
XFILLER_90_139 VGND VGND VPWR VPWR sky130_fd_sc_hd__fill_1
XFILLER_8_413 VGND VGND VPWR VPWR sky130_fd_sc_hd__decap_6
XFILLER_8_457 VPWR VGND VPWR VGND sky130_ef_sc_hd__decap_12
X_3090_ _1525_ _1546_ VGND VGND VPWR VPWR _1547_ sky130_fd_sc_hd__nor2_1
X_2110_ _0979_ _0987_ VGND VGND VPWR VPWR _0988_ sky130_fd_sc_hd__xnor2_2
Xhold2 startup_reset\[2\] VGND VGND VPWR VPWR net158 sky130_fd_sc_hd__dlygate4sd3_1
X_2041_ net310 net85 _0958_ VGND VGND VPWR VPWR _0149_ sky130_fd_sc_hd__mux2_1
XFILLER_35_523 VPWR VGND VPWR VGND sky130_ef_sc_hd__decap_12
XTAP_TAPCELL_ROW_65_816 VGND VPWR sky130_fd_sc_hd__tapvpwrvgnd_1
XFILLER_62_342 VGND VGND VPWR VPWR sky130_fd_sc_hd__fill_2
X_2943_ u_uart_rx.low_count\[2\] _1472_ _1473_ VGND VGND VPWR VPWR _0536_ sky130_fd_sc_hd__o21a_1
XFILLER_50_526 VGND VGND VPWR VPWR sky130_fd_sc_hd__decap_6
XTAP_TAPCELL_ROW_73_893 VGND VPWR sky130_fd_sc_hd__tapvpwrvgnd_1
XFILLER_15_291 VGND VGND VPWR VPWR sky130_fd_sc_hd__decap_3
X_2874_ net375 net23 _1437_ VGND VGND VPWR VPWR _0503_ sky130_fd_sc_hd__mux2_1
X_1825_ u_rx_fifo.wr_ptr\[3\] u_rx_fifo.wr_ptr\[2\] VGND VGND VPWR VPWR _0873_ sky130_fd_sc_hd__nand2b_2
X_1756_ u_uart_rx.break_detect u_uart_rx.state\[0\] VGND VGND VPWR VPWR _0820_ sky130_fd_sc_hd__or2_1
Xhold402 u_parser.u_packet_encoder.tag_latched\[26\] VGND VGND VPWR VPWR net558 sky130_fd_sc_hd__dlygate4sd3_1
Xhold435 u_parser.u_decoder.ascii_buf\[10\]\[5\] VGND VGND VPWR VPWR net591 sky130_fd_sc_hd__dlygate4sd3_1
Xhold413 u_rx_fifo.level\[4\] VGND VGND VPWR VPWR net569 sky130_fd_sc_hd__dlygate4sd3_1
Xhold424 u_uart_rx.low_count\[12\] VGND VGND VPWR VPWR net580 sky130_fd_sc_hd__dlygate4sd3_1
Xhold468 u_uart_rx.sample_div_count\[4\] VGND VGND VPWR VPWR net624 sky130_fd_sc_hd__dlygate4sd3_1
Xhold457 u_uart_rx.sample_div_count\[2\] VGND VGND VPWR VPWR net613 sky130_fd_sc_hd__dlygate4sd3_1
Xhold446 u_parser.u_decoder.ascii_buf\[4\]\[7\] VGND VGND VPWR VPWR net602 sky130_fd_sc_hd__dlygate4sd3_1
X_1687_ net145 _0753_ VGND VGND VPWR VPWR _0754_ sky130_fd_sc_hd__or2_1
XFILLER_89_239 VPWR VGND VPWR VGND sky130_ef_sc_hd__decap_12
Xhold479 u_uart_rx.sample_div_count\[14\] VGND VGND VPWR VPWR net635 sky130_fd_sc_hd__dlygate4sd3_1
X_3426_ clknet_leaf_61_clk _0259_ net88 VGND VGND VPWR VPWR u_uart_tx.tx_data\[2\]
+ sky130_fd_sc_hd__dfrtp_1
X_3357_ clknet_leaf_48_clk _0190_ net102 VGND VGND VPWR VPWR u_parser.u_packet_encoder.crc_latched\[1\]
+ sky130_fd_sc_hd__dfrtp_1
X_2308_ _0681_ _1112_ VGND VGND VPWR VPWR _1113_ sky130_fd_sc_hd__or2_1
X_3288_ clknet_leaf_21_clk _0124_ VGND VGND VPWR VPWR u_rx_fifo.mem\[8\]\[7\] sky130_fd_sc_hd__dfxtp_1
X_2239_ _0879_ _0882_ net51 u_parser.u_packet_encoder.byte_index\[3\] VGND VGND VPWR
+ VPWR _1066_ sky130_fd_sc_hd__o211a_1
XFILLER_26_501 VGND VGND VPWR VPWR sky130_fd_sc_hd__fill_1
XFILLER_26_545 VGND VGND VPWR VPWR sky130_fd_sc_hd__decap_8
XFILLER_54_27 VGND VGND VPWR VPWR sky130_fd_sc_hd__fill_1
XFILLER_13_206 VGND VGND VPWR VPWR sky130_fd_sc_hd__fill_1
XTAP_TAPCELL_ROW_36_540 VGND VPWR sky130_fd_sc_hd__tapvpwrvgnd_1
XFILLER_54_49 VGND VGND VPWR VPWR sky130_fd_sc_hd__fill_2
XTAP_TAPCELL_ROW_0_198 VGND VPWR sky130_fd_sc_hd__tapvpwrvgnd_1
XFILLER_70_15 VPWR VGND VPWR VGND sky130_ef_sc_hd__decap_12
XFILLER_21_272 VGND VGND VPWR VPWR sky130_fd_sc_hd__decap_8
XFILLER_5_405 VPWR VGND VPWR VGND sky130_ef_sc_hd__decap_12
XFILLER_5_449 VPWR VGND VPWR VGND sky130_ef_sc_hd__decap_12
XTAP_TAPCELL_ROW_8_276 VGND VPWR sky130_fd_sc_hd__tapvpwrvgnd_1
XFILLER_0_165 VGND VGND VPWR VPWR sky130_fd_sc_hd__decap_3
XFILLER_76_467 VGND VGND VPWR VPWR sky130_fd_sc_hd__decap_8
XFILLER_36_309 VGND VGND VPWR VPWR sky130_fd_sc_hd__fill_1
XFILLER_76_489 VGND VGND VPWR VPWR sky130_fd_sc_hd__fill_2
XFILLER_28_83 VGND VGND VPWR VPWR sky130_fd_sc_hd__fill_1
XFILLER_91_459 VPWR VGND VPWR VGND sky130_ef_sc_hd__decap_12
XFILLER_44_397 VGND VGND VPWR VPWR sky130_fd_sc_hd__fill_2
XFILLER_71_194 VPWR VGND VPWR VGND sky130_ef_sc_hd__decap_12
XTAP_TAPCELL_ROW_70_863 VGND VPWR sky130_fd_sc_hd__tapvpwrvgnd_1
XTAP_TAPCELL_ROW_42_598 VGND VPWR sky130_fd_sc_hd__tapvpwrvgnd_1
X_1610_ u_parser.u_decoder.decoded_checksum_calc\[4\] VGND VGND VPWR VPWR _0680_ sky130_fd_sc_hd__inv_2
X_2590_ _1282_ u_parser.u_decoder.ascii_buf\[3\]\[1\] u_parser.u_decoder.ascii_buf\[3\]\[0\]
+ VGND VGND VPWR VPWR _1288_ sky130_fd_sc_hd__and3b_1
X_3211_ clknet_leaf_10_clk _0047_ VGND VGND VPWR VPWR u_rx_fifo.mem\[13\]\[2\] sky130_fd_sc_hd__dfxtp_1
X_3142_ net59 _1574_ _1575_ _1576_ VGND VGND VPWR VPWR _0632_ sky130_fd_sc_hd__a31o_1
XFILLER_79_272 VGND VGND VPWR VPWR sky130_fd_sc_hd__decap_8
XTAP_TAPCELL_ROW_78_941 VGND VPWR sky130_fd_sc_hd__tapvpwrvgnd_1
X_3073_ u_uart_rx.sample_div_count\[7\] _1534_ VGND VGND VPWR VPWR _1535_ sky130_fd_sc_hd__or2_1
X_2024_ net246 net25 _0956_ VGND VGND VPWR VPWR _0134_ sky130_fd_sc_hd__mux2_1
XFILLER_23_537 VPWR VGND VPWR VGND sky130_ef_sc_hd__decap_12
X_2926_ u_uart_tx.clk_count\[12\] _1462_ VGND VGND VPWR VPWR _1464_ sky130_fd_sc_hd__or2_1
X_2857_ net146 _1431_ VGND VGND VPWR VPWR _1433_ sky130_fd_sc_hd__nand2_1
XFILLER_40_29 VPWR VGND VPWR VGND sky130_ef_sc_hd__decap_12
X_1808_ _0706_ _0848_ _0797_ VGND VGND VPWR VPWR _0861_ sky130_fd_sc_hd__or3b_1
X_2788_ net636 net42 _1408_ VGND VGND VPWR VPWR _0446_ sky130_fd_sc_hd__mux2_1
Xhold210 u_rx_fifo.mem\[6\]\[2\] VGND VGND VPWR VPWR net366 sky130_fd_sc_hd__dlygate4sd3_1
Xhold232 u_rx_fifo.mem\[3\]\[7\] VGND VGND VPWR VPWR net388 sky130_fd_sc_hd__dlygate4sd3_1
XFILLER_2_419 VGND VGND VPWR VPWR sky130_fd_sc_hd__fill_1
Xhold221 u_tx_fifo.mem\[3\]\[6\] VGND VGND VPWR VPWR net377 sky130_fd_sc_hd__dlygate4sd3_1
X_1739_ u_parser.u_decoder.decoded_checksum_rx\[3\] u_parser.u_decoder.decoded_checksum_calc\[3\]
+ VGND VGND VPWR VPWR _0805_ sky130_fd_sc_hd__xnor2_1
Xhold243 u_rx_fifo.mem\[5\]\[4\] VGND VGND VPWR VPWR net399 sky130_fd_sc_hd__dlygate4sd3_1
Xhold265 u_uart_rx.low_count\[21\] VGND VGND VPWR VPWR net421 sky130_fd_sc_hd__dlygate4sd3_1
Xhold254 u_rx_fifo.mem\[1\]\[2\] VGND VGND VPWR VPWR net410 sky130_fd_sc_hd__dlygate4sd3_1
Xhold276 u_parser.u_decoder.decoded_payload\[21\] VGND VGND VPWR VPWR net432 sky130_fd_sc_hd__dlygate4sd3_1
Xhold287 u_parser.u_decoder.decoded_payload\[22\] VGND VGND VPWR VPWR net443 sky130_fd_sc_hd__dlygate4sd3_1
XFILLER_49_27 VPWR VGND VPWR VGND sky130_ef_sc_hd__decap_12
Xhold298 u_parser.u_decoder.decoded_payload\[19\] VGND VGND VPWR VPWR net454 sky130_fd_sc_hd__dlygate4sd3_1
X_3409_ clknet_leaf_7_clk _0242_ VGND VGND VPWR VPWR u_tx_fifo.mem\[2\]\[1\] sky130_fd_sc_hd__dfxtp_1
XTAP_TAPCELL_ROW_5_246 VGND VPWR sky130_fd_sc_hd__tapvpwrvgnd_1
XFILLER_58_401 VPWR VGND VPWR VGND sky130_ef_sc_hd__decap_12
XFILLER_65_15 VPWR VGND VPWR VGND sky130_ef_sc_hd__decap_12
XTAP_TAPCELL_ROW_86_1018 VGND VPWR sky130_fd_sc_hd__tapvpwrvgnd_1
XTAP_TAPCELL_ROW_84_999 VGND VPWR sky130_fd_sc_hd__tapvpwrvgnd_1
XFILLER_5_279 VGND VGND VPWR VPWR sky130_fd_sc_hd__fill_1
XFILLER_1_441 VGND VGND VPWR VPWR sky130_fd_sc_hd__decap_6
XFILLER_1_485 VPWR VGND VPWR VGND sky130_ef_sc_hd__decap_12
XFILLER_76_275 VGND VGND VPWR VPWR sky130_fd_sc_hd__fill_1
XFILLER_76_253 VPWR VGND VPWR VGND sky130_ef_sc_hd__decap_12
XTAP_TAPCELL_ROW_75_911 VGND VPWR sky130_fd_sc_hd__tapvpwrvgnd_1
XFILLER_29_180 VGND VGND VPWR VPWR sky130_fd_sc_hd__decap_6
XTAP_TAPCELL_ROW_47_646 VGND VPWR sky130_fd_sc_hd__tapvpwrvgnd_1
XFILLER_91_256 VGND VGND VPWR VPWR sky130_fd_sc_hd__decap_3
X_3760_ clknet_leaf_12_clk _0578_ VGND VGND VPWR VPWR u_rx_fifo.mem\[9\]\[1\] sky130_fd_sc_hd__dfxtp_1
XFILLER_9_541 VPWR VGND VPWR VGND sky130_ef_sc_hd__decap_12
X_2711_ _0743_ net586 _1373_ VGND VGND VPWR VPWR _0404_ sky130_fd_sc_hd__mux2_1
X_3691_ clknet_leaf_60_clk _0656_ net91 VGND VGND VPWR VPWR u_uart_tx.state\[1\] sky130_fd_sc_hd__dfrtp_1
X_2642_ u_parser.u_decoder.ascii_buf\[0\]\[3\] u_parser.u_decoder.ascii_buf\[0\]\[4\]
+ u_parser.u_decoder.ascii_buf\[0\]\[7\] u_parser.u_decoder.ascii_buf\[0\]\[6\] VGND
+ VGND VPWR VPWR _1329_ sky130_fd_sc_hd__or4b_1
XFILLER_65_3 VPWR VGND VPWR VGND sky130_ef_sc_hd__decap_12
XTAP_TAPCELL_ROW_10_292 VGND VPWR sky130_fd_sc_hd__tapvpwrvgnd_1
X_2573_ u_parser.u_decoder.ascii_buf\[4\]\[1\] _1269_ VGND VGND VPWR VPWR _1275_ sky130_fd_sc_hd__xnor2_1
XFILLER_87_529 VPWR VGND VPWR VGND sky130_ef_sc_hd__decap_12
X_3125_ u_uart_rx.sample_phase\[1\] u_uart_rx.sample_phase\[2\] u_uart_rx.sample_phase\[3\]
+ VGND VGND VPWR VPWR _1563_ sky130_fd_sc_hd__o21ai_1
XTAP_TAPCELL_ROW_2_216 VGND VPWR sky130_fd_sc_hd__tapvpwrvgnd_1
XFILLER_27_106 VGND VGND VPWR VPWR sky130_fd_sc_hd__decap_6
X_3056_ u_uart_rx.sample_div_count\[0\] _1509_ u_uart_rx.sample_div_count\[1\] VGND
+ VGND VPWR VPWR _1524_ sky130_fd_sc_hd__a21o_1
XFILLER_67_297 VPWR VGND VPWR VGND sky130_ef_sc_hd__decap_12
XFILLER_42_109 VPWR VGND VPWR VGND sky130_ef_sc_hd__decap_12
X_2007_ net213 net78 _0953_ VGND VGND VPWR VPWR _0120_ sky130_fd_sc_hd__mux2_1
XTAP_TAPCELL_ROW_18_370 VGND VPWR sky130_fd_sc_hd__tapvpwrvgnd_1
XTAP_TAPCELL_ROW_81_969 VGND VPWR sky130_fd_sc_hd__tapvpwrvgnd_1
XFILLER_11_529 VPWR VGND VPWR VGND sky130_ef_sc_hd__decap_12
XFILLER_23_389 VGND VGND VPWR VPWR sky130_fd_sc_hd__decap_3
XFILLER_50_175 VGND VGND VPWR VPWR sky130_fd_sc_hd__decap_4
XFILLER_50_197 VGND VGND VPWR VPWR sky130_fd_sc_hd__decap_6
XFILLER_51_39 VPWR VGND VPWR VGND sky130_ef_sc_hd__decap_12
X_2909_ net652 _1450_ net6 VGND VGND VPWR VPWR _1453_ sky130_fd_sc_hd__o21ai_1
XTAP_TAPCELL_ROW_92_1077 VGND VPWR sky130_fd_sc_hd__tapvpwrvgnd_1
XFILLER_76_47 VGND VGND VPWR VPWR sky130_fd_sc_hd__fill_1
XFILLER_18_106 VGND VGND VPWR VPWR sky130_fd_sc_hd__fill_1
XFILLER_18_139 VGND VGND VPWR VPWR sky130_fd_sc_hd__fill_1
XFILLER_73_212 VPWR VGND VPWR VGND sky130_ef_sc_hd__decap_12
XTAP_TAPCELL_ROW_44_616 VGND VPWR sky130_fd_sc_hd__tapvpwrvgnd_1
XFILLER_14_356 VGND VGND VPWR VPWR sky130_fd_sc_hd__fill_1
XFILLER_41_164 VGND VGND VPWR VPWR sky130_fd_sc_hd__decap_4
XFILLER_41_175 VGND VGND VPWR VPWR sky130_fd_sc_hd__fill_1
XTAP_TAPCELL_ROW_52_693 VGND VPWR sky130_fd_sc_hd__tapvpwrvgnd_1
XFILLER_6_533 VPWR VGND VPWR VGND sky130_ef_sc_hd__decap_12
XFILLER_1_271 VGND VGND VPWR VPWR sky130_fd_sc_hd__decap_8
X_3812_ clknet_leaf_27_clk _0629_ net123 VGND VGND VPWR VPWR u_uart_rx.vote_ones\[0\]
+ sky130_fd_sc_hd__dfrtp_1
XTAP_TAPCELL_ROW_15_340 VGND VPWR sky130_fd_sc_hd__tapvpwrvgnd_1
XFILLER_20_326 VGND VGND VPWR VPWR sky130_fd_sc_hd__fill_1
X_3743_ clknet_leaf_64_clk _0567_ VGND VGND VPWR VPWR u_tx_fifo.mem\[8\]\[6\] sky130_fd_sc_hd__dfxtp_1
XFILLER_9_393 VPWR VGND VPWR VGND sky130_ef_sc_hd__decap_12
XFILLER_9_382 VGND VGND VPWR VPWR sky130_fd_sc_hd__decap_8
X_3674_ clknet_leaf_63_clk _0501_ VGND VGND VPWR VPWR u_tx_fifo.mem\[10\]\[0\] sky130_fd_sc_hd__dfxtp_1
X_2625_ u_parser.u_decoder.ascii_buf\[1\]\[0\] u_parser.u_decoder.ascii_buf\[1\]\[1\]
+ u_parser.u_decoder.ascii_buf\[1\]\[2\] _0686_ _1315_ VGND VGND VPWR VPWR _1316_
+ sky130_fd_sc_hd__o311a_1
X_2556_ _1258_ _1261_ VGND VGND VPWR VPWR _1262_ sky130_fd_sc_hd__and2_1
X_2487_ net468 _1206_ net10 VGND VGND VPWR VPWR _0347_ sky130_fd_sc_hd__mux2_1
X_3108_ u_uart_rx.bit_index\[2\] _1557_ _1558_ VGND VGND VPWR VPWR _0616_ sky130_fd_sc_hd__o21a_1
XFILLER_83_543 VPWR VGND VPWR VGND sky130_ef_sc_hd__decap_12
X_3039_ _1509_ _1512_ VGND VGND VPWR VPWR _1513_ sky130_fd_sc_hd__nand2_2
XFILLER_62_27 VGND VGND VPWR VPWR sky130_fd_sc_hd__fill_1
XFILLER_62_49 VGND VGND VPWR VPWR sky130_fd_sc_hd__decap_3
XFILLER_11_337 VGND VGND VPWR VPWR sky130_fd_sc_hd__decap_8
XFILLER_11_326 VGND VGND VPWR VPWR sky130_fd_sc_hd__fill_1
XFILLER_7_319 VGND VGND VPWR VPWR sky130_fd_sc_hd__decap_4
XFILLER_3_503 VGND VGND VPWR VPWR sky130_fd_sc_hd__fill_1
XTAP_TAPCELL_ROW_21_398 VGND VPWR sky130_fd_sc_hd__tapvpwrvgnd_1
XFILLER_86_381 VPWR VGND VPWR VGND sky130_ef_sc_hd__decap_12
XTAP_TAPCELL_ROW_57_741 VGND VPWR sky130_fd_sc_hd__tapvpwrvgnd_1
XTAP_TAPCELL_ROW_29_476 VGND VPWR sky130_fd_sc_hd__tapvpwrvgnd_1
XFILLER_14_153 VGND VGND VPWR VPWR sky130_fd_sc_hd__fill_2
XFILLER_6_396 VPWR VGND VPWR VGND sky130_ef_sc_hd__decap_12
X_2410_ net155 _0817_ VGND VGND VPWR VPWR _1152_ sky130_fd_sc_hd__or2_2
X_3390_ clknet_leaf_46_clk _0223_ net109 VGND VGND VPWR VPWR u_parser.u_packet_encoder.tag_latched\[26\]
+ sky130_fd_sc_hd__dfrtp_1
X_2341_ u_parser.u_decoder.decoded_checksum_rx\[3\] _0678_ _0679_ u_parser.u_decoder.decoded_checksum_calc\[4\]
+ VGND VGND VPWR VPWR _1135_ sky130_fd_sc_hd__o22a_1
X_2272_ _0681_ _1080_ VGND VGND VPWR VPWR _1081_ sky130_fd_sc_hd__or2_1
XFILLER_69_337 VPWR VGND VPWR VGND sky130_ef_sc_hd__decap_12
XFILLER_28_3 VPWR VGND VPWR VGND sky130_ef_sc_hd__decap_12
XFILLER_84_329 VGND VGND VPWR VPWR sky130_fd_sc_hd__decap_3
XFILLER_92_340 VGND VGND VPWR VPWR sky130_fd_sc_hd__decap_4
XFILLER_37_245 VGND VGND VPWR VPWR sky130_fd_sc_hd__decap_3
XFILLER_65_543 VPWR VGND VPWR VGND sky130_ef_sc_hd__decap_12
XFILLER_92_373 VGND VGND VPWR VPWR sky130_fd_sc_hd__fill_2
XFILLER_92_362 VGND VGND VPWR VPWR sky130_fd_sc_hd__fill_2
XFILLER_25_418 VGND VGND VPWR VPWR sky130_fd_sc_hd__decap_3
XFILLER_37_278 VGND VGND VPWR VPWR sky130_fd_sc_hd__fill_2
XTAP_TAPCELL_ROW_63_799 VGND VPWR sky130_fd_sc_hd__tapvpwrvgnd_1
X_1987_ net78 net319 _0949_ VGND VGND VPWR VPWR _0104_ sky130_fd_sc_hd__mux2_1
X_3726_ clknet_leaf_29_clk _0550_ net140 VGND VGND VPWR VPWR u_uart_rx.low_count\[16\]
+ sky130_fd_sc_hd__dfrtp_1
X_3657_ clknet_leaf_59_clk _0484_ net91 VGND VGND VPWR VPWR u_tx_fifo.level\[4\] sky130_fd_sc_hd__dfrtp_1
X_2608_ _1296_ u_parser.u_decoder.ascii_buf\[2\]\[1\] u_parser.u_decoder.ascii_buf\[2\]\[0\]
+ VGND VGND VPWR VPWR _1302_ sky130_fd_sc_hd__and3b_1
X_3588_ clknet_leaf_33_clk _0415_ net133 VGND VGND VPWR VPWR u_parser.u_decoder.ascii_buf\[7\]\[7\]
+ sky130_fd_sc_hd__dfrtp_1
XFILLER_0_517 VPWR VGND VPWR VGND sky130_ef_sc_hd__decap_12
X_2539_ net424 _1248_ net8 VGND VGND VPWR VPWR _0357_ sky130_fd_sc_hd__mux2_1
XFILLER_57_27 VPWR VGND VPWR VGND sky130_ef_sc_hd__decap_12
XTAP_TAPCELL_ROW_54_711 VGND VPWR sky130_fd_sc_hd__tapvpwrvgnd_1
XFILLER_73_15 VPWR VGND VPWR VGND sky130_ef_sc_hd__decap_12
XTAP_TAPCELL_ROW_26_446 VGND VPWR sky130_fd_sc_hd__tapvpwrvgnd_1
XFILLER_51_281 VPWR VGND VPWR VGND sky130_ef_sc_hd__decap_12
XFILLER_22_85 VGND VGND VPWR VPWR sky130_fd_sc_hd__decap_6
XFILLER_66_307 VGND VGND VPWR VPWR sky130_fd_sc_hd__fill_1
XFILLER_14_9 VGND VGND VPWR VPWR sky130_fd_sc_hd__fill_1
XFILLER_19_223 VGND VGND VPWR VPWR sky130_fd_sc_hd__fill_1
XFILLER_47_93 VPWR VGND VPWR VGND sky130_ef_sc_hd__decap_12
X_2890_ _0661_ u_uart_tx.state\[1\] _0825_ _0831_ VGND VGND VPWR VPWR _1440_ sky130_fd_sc_hd__a31o_1
X_1910_ u_parser.u_packet_encoder.tag_latched\[38\] _0896_ _0899_ u_parser.u_packet_encoder.tag_latched\[22\]
+ VGND VGND VPWR VPWR _0934_ sky130_fd_sc_hd__a22o_1
X_1841_ net219 net82 _0885_ VGND VGND VPWR VPWR _0022_ sky130_fd_sc_hd__mux2_1
XTAP_TAPCELL_ROW_60_769 VGND VPWR sky130_fd_sc_hd__tapvpwrvgnd_1
XFILLER_30_498 VGND VGND VPWR VPWR sky130_fd_sc_hd__fill_1
X_1772_ net643 _0830_ _0831_ net50 VGND VGND VPWR VPWR _0655_ sky130_fd_sc_hd__a211o_1
X_3511_ clknet_leaf_29_clk _0338_ net137 VGND VGND VPWR VPWR u_parser.u_decoder.timeout_count\[13\]
+ sky130_fd_sc_hd__dfrtp_1
X_3442_ clknet_leaf_27_clk _0005_ net124 VGND VGND VPWR VPWR u_uart_rx.state\[2\]
+ sky130_fd_sc_hd__dfrtp_2
X_3373_ clknet_3_2__leaf_clk _0206_ net103 VGND VGND VPWR VPWR u_parser.u_packet_encoder.tag_latched\[9\]
+ sky130_fd_sc_hd__dfrtp_1
X_2324_ u_tx_fifo.mem\[8\]\[7\] u_tx_fifo.mem\[9\]\[7\] u_tx_fifo.mem\[10\]\[7\] u_tx_fifo.mem\[11\]\[7\]
+ net66 net62 VGND VGND VPWR VPWR _1127_ sky130_fd_sc_hd__mux4_1
XFILLER_84_137 VGND VGND VPWR VPWR sky130_fd_sc_hd__decap_3
X_2255_ net74 net300 _0876_ VGND VGND VPWR VPWR _0254_ sky130_fd_sc_hd__mux2_1
XTAP_TAPCELL_ROW_68_847 VGND VPWR sky130_fd_sc_hd__tapvpwrvgnd_1
X_2186_ _1053_ _1057_ net52 VGND VGND VPWR VPWR _1059_ sky130_fd_sc_hd__o21ba_1
XFILLER_27_19 VGND VGND VPWR VPWR sky130_fd_sc_hd__fill_1
XFILLER_80_365 VGND VGND VPWR VPWR sky130_fd_sc_hd__fill_1
XTAP_TAPCELL_ROW_23_416 VGND VPWR sky130_fd_sc_hd__tapvpwrvgnd_1
XTAP_TAPCELL_ROW_31_493 VGND VPWR sky130_fd_sc_hd__tapvpwrvgnd_1
X_3709_ clknet_leaf_60_clk _0533_ net91 VGND VGND VPWR VPWR net2 sky130_fd_sc_hd__dfstp_1
XFILLER_68_15 VPWR VGND VPWR VGND sky130_ef_sc_hd__decap_12
XFILLER_88_432 VGND VGND VPWR VPWR sky130_fd_sc_hd__fill_1
XFILLER_88_498 VPWR VGND VPWR VGND sky130_ef_sc_hd__decap_12
XTAP_TAPCELL_ROW_89_1049 VGND VPWR sky130_fd_sc_hd__tapvpwrvgnd_1
XFILLER_29_554 VGND VGND VPWR VPWR sky130_fd_sc_hd__fill_1
XTAP_TAPCELL_ROW_39_571 VGND VPWR sky130_fd_sc_hd__tapvpwrvgnd_1
XFILLER_56_373 VGND VGND VPWR VPWR sky130_fd_sc_hd__fill_2
XFILLER_12_421 VPWR VGND VPWR VGND sky130_ef_sc_hd__decap_12
XFILLER_8_469 VGND VGND VPWR VPWR sky130_fd_sc_hd__decap_6
XFILLER_3_141 VGND VGND VPWR VPWR sky130_fd_sc_hd__decap_6
XFILLER_79_487 VGND VGND VPWR VPWR sky130_fd_sc_hd__fill_2
Xhold3 startup_reset\[0\] VGND VGND VPWR VPWR net159 sky130_fd_sc_hd__dlygate4sd3_1
X_2040_ _0873_ _0886_ VGND VGND VPWR VPWR _0958_ sky130_fd_sc_hd__nor2_4
XTAP_TAPCELL_ROW_65_817 VGND VPWR sky130_fd_sc_hd__tapvpwrvgnd_1
XFILLER_35_535 VPWR VGND VPWR VGND sky130_ef_sc_hd__decap_12
X_2942_ u_uart_rx.low_count\[2\] _1472_ net87 VGND VGND VPWR VPWR _1473_ sky130_fd_sc_hd__a21oi_1
XTAP_TAPCELL_ROW_73_894 VGND VPWR sky130_fd_sc_hd__tapvpwrvgnd_1
XFILLER_15_281 VGND VGND VPWR VPWR sky130_fd_sc_hd__fill_2
X_2873_ net278 net25 _1437_ VGND VGND VPWR VPWR _0502_ sky130_fd_sc_hd__mux2_1
XFILLER_30_251 VGND VGND VPWR VPWR sky130_fd_sc_hd__fill_1
X_1824_ _0871_ _0872_ VGND VGND VPWR VPWR _0018_ sky130_fd_sc_hd__nor2_1
X_1755_ _0783_ _0812_ _0815_ _0819_ VGND VGND VPWR VPWR _0002_ sky130_fd_sc_hd__a31o_1
Xhold403 u_parser.u_packet_encoder.crc_latched\[1\] VGND VGND VPWR VPWR net559 sky130_fd_sc_hd__dlygate4sd3_1
Xhold414 u_parser.u_decoder.ascii_buf\[0\]\[7\] VGND VGND VPWR VPWR net570 sky130_fd_sc_hd__dlygate4sd3_1
Xhold436 u_parser.u_decoder.ascii_buf\[11\]\[4\] VGND VGND VPWR VPWR net592 sky130_fd_sc_hd__dlygate4sd3_1
Xhold425 _0546_ VGND VGND VPWR VPWR net581 sky130_fd_sc_hd__dlygate4sd3_1
Xhold469 u_uart_tx.clk_count\[8\] VGND VGND VPWR VPWR net625 sky130_fd_sc_hd__dlygate4sd3_1
Xhold447 u_parser.u_decoder.ascii_buf\[1\]\[7\] VGND VGND VPWR VPWR net603 sky130_fd_sc_hd__dlygate4sd3_1
Xhold458 u_parser.u_decoder.ascii_buf\[11\]\[5\] VGND VGND VPWR VPWR net614 sky130_fd_sc_hd__dlygate4sd3_1
X_1686_ u_rx_fifo.mem\[8\]\[1\] u_rx_fifo.mem\[9\]\[1\] u_rx_fifo.mem\[10\]\[1\] u_rx_fifo.mem\[11\]\[1\]
+ net151 net147 VGND VGND VPWR VPWR _0753_ sky130_fd_sc_hd__mux4_1
X_3425_ clknet_leaf_59_clk _0258_ net88 VGND VGND VPWR VPWR u_uart_tx.tx_data\[1\]
+ sky130_fd_sc_hd__dfrtp_1
X_3356_ clknet_leaf_49_clk _0189_ net102 VGND VGND VPWR VPWR u_parser.u_packet_encoder.crc_latched\[0\]
+ sky130_fd_sc_hd__dfrtp_1
X_2307_ u_tx_fifo.mem\[12\]\[5\] u_tx_fifo.mem\[13\]\[5\] u_tx_fifo.mem\[14\]\[5\]
+ u_tx_fifo.mem\[15\]\[5\] net66 net62 VGND VGND VPWR VPWR _1112_ sky130_fd_sc_hd__mux4_1
XFILLER_38_29 VPWR VGND VPWR VGND sky130_ef_sc_hd__decap_12
X_3287_ clknet_leaf_10_clk _0123_ VGND VGND VPWR VPWR u_rx_fifo.mem\[8\]\[6\] sky130_fd_sc_hd__dfxtp_1
X_2238_ net51 _1064_ _1065_ VGND VGND VPWR VPWR _0239_ sky130_fd_sc_hd__and3_1
X_2169_ _1044_ net573 net51 VGND VGND VPWR VPWR _0191_ sky130_fd_sc_hd__mux2_1
XTAP_TAPCELL_ROW_0_188 VGND VPWR sky130_fd_sc_hd__tapvpwrvgnd_1
XTAP_TAPCELL_ROW_36_541 VGND VPWR sky130_fd_sc_hd__tapvpwrvgnd_1
XFILLER_41_505 VPWR VGND VPWR VGND sky130_ef_sc_hd__decap_12
XTAP_TAPCELL_ROW_0_199 VGND VPWR sky130_fd_sc_hd__tapvpwrvgnd_1
XFILLER_70_27 VGND VGND VPWR VPWR sky130_fd_sc_hd__fill_1
XFILLER_5_417 VPWR VGND VPWR VGND sky130_ef_sc_hd__decap_12
XFILLER_0_111 VGND VGND VPWR VPWR sky130_fd_sc_hd__fill_1
XFILLER_88_251 VGND VGND VPWR VPWR sky130_fd_sc_hd__fill_1
XTAP_TAPCELL_ROW_8_277 VGND VPWR sky130_fd_sc_hd__tapvpwrvgnd_1
XFILLER_0_133 VGND VGND VPWR VPWR sky130_fd_sc_hd__decap_6
XFILLER_0_122 VGND VGND VPWR VPWR sky130_fd_sc_hd__decap_3
XFILLER_71_140 VGND VGND VPWR VPWR sky130_fd_sc_hd__fill_2
XFILLER_44_83 VGND VGND VPWR VPWR sky130_fd_sc_hd__fill_1
XTAP_TAPCELL_ROW_70_864 VGND VPWR sky130_fd_sc_hd__tapvpwrvgnd_1
XTAP_TAPCELL_ROW_42_599 VGND VPWR sky130_fd_sc_hd__tapvpwrvgnd_1
X_3210_ clknet_leaf_21_clk _0046_ VGND VGND VPWR VPWR u_rx_fifo.mem\[13\]\[1\] sky130_fd_sc_hd__dfxtp_1
XFILLER_69_80 VGND VGND VPWR VPWR sky130_fd_sc_hd__fill_1
X_3141_ u_uart_rx.bit_index\[1\] _0663_ _1573_ u_uart_rx.rx_shift\[1\] VGND VGND VPWR
+ VPWR _1576_ sky130_fd_sc_hd__o31a_1
XTAP_TAPCELL_ROW_78_942 VGND VPWR sky130_fd_sc_hd__tapvpwrvgnd_1
XFILLER_10_3 VPWR VGND VPWR VGND sky130_ef_sc_hd__decap_12
X_3072_ _1525_ _1533_ _1534_ VGND VGND VPWR VPWR _0604_ sky130_fd_sc_hd__nor3_1
X_2023_ net169 net27 _0956_ VGND VGND VPWR VPWR _0133_ sky130_fd_sc_hd__mux2_1
XFILLER_47_181 VGND VGND VPWR VPWR sky130_fd_sc_hd__decap_3
XTAP_TAPCELL_ROW_33_511 VGND VPWR sky130_fd_sc_hd__tapvpwrvgnd_1
XFILLER_23_549 VGND VGND VPWR VPWR sky130_fd_sc_hd__decap_6
X_2925_ _1462_ _1463_ VGND VGND VPWR VPWR _0528_ sky130_fd_sc_hd__nor2_1
X_2856_ _1431_ _1432_ VGND VGND VPWR VPWR _0490_ sky130_fd_sc_hd__nor2_1
X_1807_ u_rx_fifo.level\[2\] _0860_ _0852_ VGND VGND VPWR VPWR _0013_ sky130_fd_sc_hd__mux2_1
Xhold211 u_tx_fifo.mem\[14\]\[6\] VGND VGND VPWR VPWR net367 sky130_fd_sc_hd__dlygate4sd3_1
Xhold200 u_tx_fifo.mem\[2\]\[2\] VGND VGND VPWR VPWR net356 sky130_fd_sc_hd__dlygate4sd3_1
X_2787_ net610 net35 _1408_ VGND VGND VPWR VPWR _0445_ sky130_fd_sc_hd__mux2_1
Xhold222 u_tx_fifo.mem\[1\]\[7\] VGND VGND VPWR VPWR net378 sky130_fd_sc_hd__dlygate4sd3_1
X_1738_ _0679_ u_parser.u_decoder.decoded_checksum_calc\[4\] _0802_ _0803_ VGND VGND
+ VPWR VPWR _0804_ sky130_fd_sc_hd__o211a_1
Xhold233 u_rx_fifo.mem\[11\]\[5\] VGND VGND VPWR VPWR net389 sky130_fd_sc_hd__dlygate4sd3_1
Xhold244 u_rx_fifo.mem\[13\]\[3\] VGND VGND VPWR VPWR net400 sky130_fd_sc_hd__dlygate4sd3_1
Xhold266 u_uart_rx.sample_phase\[4\] VGND VGND VPWR VPWR net422 sky130_fd_sc_hd__dlygate4sd3_1
Xhold277 u_uart_rx.rx_shift\[7\] VGND VGND VPWR VPWR net433 sky130_fd_sc_hd__dlygate4sd3_1
X_1669_ u_rx_fifo.mem\[8\]\[6\] u_rx_fifo.mem\[9\]\[6\] u_rx_fifo.mem\[10\]\[6\] u_rx_fifo.mem\[11\]\[6\]
+ net151 net147 VGND VGND VPWR VPWR _0736_ sky130_fd_sc_hd__mux4_1
Xhold255 u_rx_fifo.mem\[15\]\[6\] VGND VGND VPWR VPWR net411 sky130_fd_sc_hd__dlygate4sd3_1
X_3408_ clknet_leaf_6_clk _0241_ VGND VGND VPWR VPWR u_tx_fifo.mem\[2\]\[0\] sky130_fd_sc_hd__dfxtp_1
Xhold288 u_parser.u_decoder.decoded_payload\[37\] VGND VGND VPWR VPWR net444 sky130_fd_sc_hd__dlygate4sd3_1
XFILLER_49_39 VPWR VGND VPWR VGND sky130_ef_sc_hd__decap_12
Xhold299 u_parser.u_decoder.decoded_payload\[27\] VGND VGND VPWR VPWR net455 sky130_fd_sc_hd__dlygate4sd3_1
XFILLER_58_413 VGND VGND VPWR VPWR sky130_fd_sc_hd__decap_6
XTAP_TAPCELL_ROW_5_247 VGND VPWR sky130_fd_sc_hd__tapvpwrvgnd_1
X_3339_ clknet_leaf_1_clk _0172_ VGND VGND VPWR VPWR u_tx_fifo.mem\[4\]\[7\] sky130_fd_sc_hd__dfxtp_1
XFILLER_65_27 VPWR VGND VPWR VGND sky130_ef_sc_hd__decap_12
XTAP_TAPCELL_ROW_86_1019 VGND VPWR sky130_fd_sc_hd__tapvpwrvgnd_1
Xclkbuf_leaf_65_clk clknet_3_0__leaf_clk VGND VGND VPWR VPWR clknet_leaf_65_clk sky130_fd_sc_hd__clkbuf_8
XFILLER_81_493 VGND VGND VPWR VPWR sky130_fd_sc_hd__decap_8
XFILLER_81_460 VGND VGND VPWR VPWR sky130_fd_sc_hd__decap_4
XFILLER_81_15 VPWR VGND VPWR VGND sky130_ef_sc_hd__decap_12
XFILLER_41_357 VGND VGND VPWR VPWR sky130_fd_sc_hd__decap_4
XFILLER_14_53 VGND VGND VPWR VPWR sky130_fd_sc_hd__fill_1
XFILLER_30_52 VGND VGND VPWR VPWR sky130_fd_sc_hd__fill_1
XFILLER_30_85 VGND VGND VPWR VPWR sky130_fd_sc_hd__fill_2
XFILLER_30_96 VGND VGND VPWR VPWR sky130_fd_sc_hd__decap_3
XFILLER_1_497 VGND VGND VPWR VPWR sky130_fd_sc_hd__decap_6
XFILLER_76_265 VGND VGND VPWR VPWR sky130_fd_sc_hd__fill_2
XTAP_TAPCELL_ROW_75_912 VGND VPWR sky130_fd_sc_hd__tapvpwrvgnd_1
XFILLER_17_310 VGND VGND VPWR VPWR sky130_fd_sc_hd__fill_2
Xclkbuf_leaf_56_clk clknet_3_1__leaf_clk VGND VGND VPWR VPWR clknet_leaf_56_clk sky130_fd_sc_hd__clkbuf_8
XTAP_TAPCELL_ROW_47_647 VGND VPWR sky130_fd_sc_hd__tapvpwrvgnd_1
XFILLER_64_438 VGND VGND VPWR VPWR sky130_fd_sc_hd__decap_4
XFILLER_17_332 VGND VGND VPWR VPWR sky130_fd_sc_hd__decap_4
XFILLER_44_195 VGND VGND VPWR VPWR sky130_fd_sc_hd__fill_1
XFILLER_9_553 VGND VGND VPWR VPWR sky130_fd_sc_hd__fill_2
X_2710_ _0718_ u_parser.u_decoder.ascii_buf\[10\]\[3\] _1373_ VGND VGND VPWR VPWR
+ _0403_ sky130_fd_sc_hd__mux2_1
XFILLER_71_70 VGND VGND VPWR VPWR sky130_fd_sc_hd__fill_1
X_3690_ clknet_leaf_60_clk _0655_ net89 VGND VGND VPWR VPWR u_uart_tx.state\[0\] sky130_fd_sc_hd__dfrtp_1
X_2641_ u_parser.u_decoder.ascii_buf\[0\]\[0\] _1327_ VGND VGND VPWR VPWR _1328_ sky130_fd_sc_hd__nand2_1
XTAP_TAPCELL_ROW_10_293 VGND VPWR sky130_fd_sc_hd__tapvpwrvgnd_1
X_2572_ u_parser.u_decoder.ascii_buf\[4\]\[5\] _1271_ _1272_ net46 VGND VGND VPWR
+ VPWR _1274_ sky130_fd_sc_hd__a211o_1
XFILLER_58_3 VPWR VGND VPWR VGND sky130_ef_sc_hd__decap_12
X_3124_ _0682_ _1561_ VGND VGND VPWR VPWR _0628_ sky130_fd_sc_hd__xnor2_1
XTAP_TAPCELL_ROW_2_217 VGND VPWR sky130_fd_sc_hd__tapvpwrvgnd_1
X_3055_ _1522_ VGND VGND VPWR VPWR _1523_ sky130_fd_sc_hd__inv_2
XFILLER_55_449 VGND VGND VPWR VPWR sky130_fd_sc_hd__decap_3
Xclkbuf_leaf_47_clk clknet_3_2__leaf_clk VGND VGND VPWR VPWR clknet_leaf_47_clk sky130_fd_sc_hd__clkbuf_8
XFILLER_35_140 VGND VGND VPWR VPWR sky130_fd_sc_hd__decap_6
X_2006_ net217 net80 _0953_ VGND VGND VPWR VPWR _0119_ sky130_fd_sc_hd__mux2_1
XTAP_TAPCELL_ROW_18_371 VGND VPWR sky130_fd_sc_hd__tapvpwrvgnd_1
XFILLER_23_335 VGND VGND VPWR VPWR sky130_fd_sc_hd__fill_1
XFILLER_50_121 VPWR VGND VPWR VGND sky130_ef_sc_hd__decap_12
X_2908_ u_uart_tx.clk_count\[6\] _1450_ VGND VGND VPWR VPWR _1452_ sky130_fd_sc_hd__and2_1
X_2839_ net646 _1423_ _1415_ VGND VGND VPWR VPWR _0482_ sky130_fd_sc_hd__mux2_1
XTAP_TAPCELL_ROW_92_1078 VGND VPWR sky130_fd_sc_hd__tapvpwrvgnd_1
XFILLER_76_15 VPWR VGND VPWR VGND sky130_ef_sc_hd__decap_12
Xclkbuf_leaf_38_clk clknet_3_6__leaf_clk VGND VGND VPWR VPWR clknet_leaf_38_clk sky130_fd_sc_hd__clkbuf_8
XFILLER_73_257 VGND VGND VPWR VPWR sky130_fd_sc_hd__fill_2
XTAP_TAPCELL_ROW_44_617 VGND VPWR sky130_fd_sc_hd__tapvpwrvgnd_1
XFILLER_73_279 VGND VGND VPWR VPWR sky130_fd_sc_hd__fill_1
XTAP_TAPCELL_ROW_52_694 VGND VPWR sky130_fd_sc_hd__tapvpwrvgnd_1
XFILLER_6_501 VPWR VGND VPWR VGND sky130_ef_sc_hd__decap_12
XFILLER_6_545 VGND VGND VPWR VPWR sky130_fd_sc_hd__decap_8
XFILLER_41_51 VGND VGND VPWR VPWR sky130_fd_sc_hd__decap_4
XFILLER_92_533 VPWR VGND VPWR VGND sky130_ef_sc_hd__decap_12
Xclkbuf_leaf_29_clk clknet_3_7__leaf_clk VGND VGND VPWR VPWR clknet_leaf_29_clk sky130_fd_sc_hd__clkbuf_8
XFILLER_60_441 VGND VGND VPWR VPWR sky130_fd_sc_hd__decap_6
XTAP_TAPCELL_ROW_15_341 VGND VPWR sky130_fd_sc_hd__tapvpwrvgnd_1
X_3811_ clknet_leaf_61_clk _0628_ net88 VGND VGND VPWR VPWR u_tx_fifo.rd_ptr\[3\]
+ sky130_fd_sc_hd__dfrtp_4
X_3742_ clknet_leaf_63_clk _0566_ VGND VGND VPWR VPWR u_tx_fifo.mem\[8\]\[5\] sky130_fd_sc_hd__dfxtp_1
X_3673_ clknet_leaf_63_clk _0500_ VGND VGND VPWR VPWR u_tx_fifo.mem\[9\]\[7\] sky130_fd_sc_hd__dfxtp_1
X_2624_ _1314_ VGND VGND VPWR VPWR _1315_ sky130_fd_sc_hd__inv_2
X_2555_ _1259_ _1260_ VGND VGND VPWR VPWR _1261_ sky130_fd_sc_hd__nor2_1
X_2486_ u_parser.u_decoder.ascii_buf\[9\]\[3\] _1194_ _1199_ VGND VGND VPWR VPWR _1206_
+ sky130_fd_sc_hd__a21o_1
X_3107_ _0664_ u_uart_rx.state\[2\] _0700_ _1554_ VGND VGND VPWR VPWR _1558_ sky130_fd_sc_hd__a31o_1
XFILLER_46_29 VPWR VGND VPWR VGND sky130_ef_sc_hd__decap_12
X_3038_ _0696_ _1510_ VGND VGND VPWR VPWR _1512_ sky130_fd_sc_hd__nand2_1
XFILLER_70_205 VGND VGND VPWR VPWR sky130_fd_sc_hd__fill_1
XFILLER_70_249 VGND VGND VPWR VPWR sky130_fd_sc_hd__decap_3
XTAP_TAPCELL_ROW_21_399 VGND VPWR sky130_fd_sc_hd__tapvpwrvgnd_1
XFILLER_86_393 VGND VGND VPWR VPWR sky130_fd_sc_hd__decap_6
XFILLER_74_533 VPWR VGND VPWR VGND sky130_ef_sc_hd__decap_12
XTAP_TAPCELL_ROW_57_742 VGND VPWR sky130_fd_sc_hd__tapvpwrvgnd_1
XTAP_TAPCELL_ROW_29_477 VGND VPWR sky130_fd_sc_hd__tapvpwrvgnd_1
XFILLER_34_408 VPWR VGND VPWR VGND sky130_ef_sc_hd__decap_12
XTAP_TAPCELL_ROW_12_311 VGND VPWR sky130_fd_sc_hd__tapvpwrvgnd_1
XFILLER_52_83 VGND VGND VPWR VPWR sky130_fd_sc_hd__fill_1
XFILLER_6_320 VPWR VGND VPWR VGND sky130_ef_sc_hd__decap_12
X_2340_ u_parser.u_decoder.decoded_checksum_rx\[1\] u_parser.u_decoder.decoded_checksum_calc\[1\]
+ VGND VGND VPWR VPWR _1134_ sky130_fd_sc_hd__xnor2_1
XFILLER_69_305 VPWR VGND VPWR VGND sky130_ef_sc_hd__decap_12
X_2271_ u_tx_fifo.mem\[12\]\[1\] u_tx_fifo.mem\[13\]\[1\] u_tx_fifo.mem\[14\]\[1\]
+ u_tx_fifo.mem\[15\]\[1\] net68 net64 VGND VGND VPWR VPWR _1080_ sky130_fd_sc_hd__mux4_1
XFILLER_69_349 VPWR VGND VPWR VGND sky130_ef_sc_hd__decap_12
XFILLER_37_268 VGND VGND VPWR VPWR sky130_fd_sc_hd__fill_1
XFILLER_52_249 VGND VGND VPWR VPWR sky130_fd_sc_hd__decap_3
X_1986_ net80 net311 _0949_ VGND VGND VPWR VPWR _0103_ sky130_fd_sc_hd__mux2_1
X_3725_ clknet_leaf_29_clk _0549_ net140 VGND VGND VPWR VPWR u_uart_rx.low_count\[15\]
+ sky130_fd_sc_hd__dfrtp_1
Xclkbuf_leaf_9_clk clknet_3_4__leaf_clk VGND VGND VPWR VPWR clknet_leaf_9_clk sky130_fd_sc_hd__clkbuf_8
X_3656_ clknet_leaf_60_clk _0483_ net89 VGND VGND VPWR VPWR u_tx_fifo.level\[3\] sky130_fd_sc_hd__dfrtp_1
X_2607_ u_parser.u_decoder.ascii_buf\[2\]\[5\] _1298_ _1299_ _1296_ VGND VGND VPWR
+ VPWR _1301_ sky130_fd_sc_hd__a211o_1
X_3587_ clknet_leaf_33_clk _0414_ net133 VGND VGND VPWR VPWR u_parser.u_decoder.ascii_buf\[7\]\[6\]
+ sky130_fd_sc_hd__dfrtp_1
XFILLER_0_529 VGND VGND VPWR VPWR sky130_fd_sc_hd__decap_3
X_2538_ _1245_ _1247_ VGND VGND VPWR VPWR _1248_ sky130_fd_sc_hd__and2_1
X_2469_ u_parser.u_decoder.ascii_buf\[9\]\[1\] u_parser.u_decoder.ascii_buf\[9\]\[2\]
+ VGND VGND VPWR VPWR _1192_ sky130_fd_sc_hd__or2_1
XFILLER_57_39 VPWR VGND VPWR VGND sky130_ef_sc_hd__decap_12
XFILLER_28_213 VGND VGND VPWR VPWR sky130_fd_sc_hd__fill_1
XFILLER_16_419 VGND VGND VPWR VPWR sky130_fd_sc_hd__fill_1
XTAP_TAPCELL_ROW_54_712 VGND VPWR sky130_fd_sc_hd__tapvpwrvgnd_1
XFILLER_71_503 VGND VGND VPWR VPWR sky130_fd_sc_hd__fill_1
XFILLER_73_27 VGND VGND VPWR VPWR sky130_fd_sc_hd__decap_4
XTAP_TAPCELL_ROW_26_447 VGND VPWR sky130_fd_sc_hd__tapvpwrvgnd_1
XFILLER_51_293 VPWR VGND VPWR VGND sky130_ef_sc_hd__decap_12
XFILLER_11_157 VGND VGND VPWR VPWR sky130_fd_sc_hd__fill_2
XFILLER_3_323 VGND VGND VPWR VPWR sky130_fd_sc_hd__fill_1
XFILLER_59_393 VGND VGND VPWR VPWR sky130_fd_sc_hd__decap_6
XFILLER_19_279 VGND VGND VPWR VPWR sky130_fd_sc_hd__fill_1
Xclkbuf_3_4__f_clk clknet_0_clk VGND VGND VPWR VPWR clknet_3_4__leaf_clk sky130_fd_sc_hd__clkbuf_16
X_1840_ net344 net84 _0885_ VGND VGND VPWR VPWR _0021_ sky130_fd_sc_hd__mux2_1
XFILLER_8_33 VGND VGND VPWR VPWR sky130_fd_sc_hd__fill_1
XPHY_EDGE_ROW_7_Left_101 VGND VGND VPWR VPWR sky130_fd_sc_hd__decap_3
XFILLER_30_466 VGND VGND VPWR VPWR sky130_fd_sc_hd__fill_1
X_1771_ u_tx_fifo.level\[4\] _0832_ _0833_ VGND VGND VPWR VPWR _0834_ sky130_fd_sc_hd__o21ba_1
X_3510_ clknet_leaf_29_clk _0337_ net137 VGND VGND VPWR VPWR u_parser.u_decoder.timeout_count\[12\]
+ sky130_fd_sc_hd__dfrtp_1
X_3441_ clknet_leaf_26_clk _0001_ net124 VGND VGND VPWR VPWR u_uart_rx.state\[1\]
+ sky130_fd_sc_hd__dfrtp_1
X_3372_ clknet_leaf_42_clk _0205_ net108 VGND VGND VPWR VPWR u_parser.u_packet_encoder.tag_latched\[8\]
+ sky130_fd_sc_hd__dfrtp_1
XFILLER_40_3 VPWR VGND VPWR VGND sky130_ef_sc_hd__decap_12
X_2323_ _1124_ _1125_ net61 VGND VGND VPWR VPWR _1126_ sky130_fd_sc_hd__mux2_1
XFILLER_69_113 VGND VGND VPWR VPWR sky130_fd_sc_hd__decap_4
XFILLER_69_157 VGND VGND VPWR VPWR sky130_fd_sc_hd__fill_1
X_2254_ net76 net287 _0876_ VGND VGND VPWR VPWR _0253_ sky130_fd_sc_hd__mux2_1
XTAP_TAPCELL_ROW_68_848 VGND VPWR sky130_fd_sc_hd__tapvpwrvgnd_1
X_2185_ _1053_ _1057_ VGND VGND VPWR VPWR _1058_ sky130_fd_sc_hd__nand2_1
XFILLER_38_533 VPWR VGND VPWR VGND sky130_ef_sc_hd__decap_12
XTAP_TAPCELL_ROW_23_417 VGND VPWR sky130_fd_sc_hd__tapvpwrvgnd_1
XFILLER_21_444 VGND VGND VPWR VPWR sky130_fd_sc_hd__decap_4
X_1969_ net302 net33 _0947_ VGND VGND VPWR VPWR _0088_ sky130_fd_sc_hd__mux2_1
XTAP_TAPCELL_ROW_31_494 VGND VPWR sky130_fd_sc_hd__tapvpwrvgnd_1
X_3708_ clknet_leaf_60_clk _0532_ net91 VGND VGND VPWR VPWR u_uart_tx.clk_count\[15\]
+ sky130_fd_sc_hd__dfrtp_1
X_3639_ clknet_leaf_35_clk _0466_ net132 VGND VGND VPWR VPWR u_parser.u_decoder.ascii_buf\[3\]\[2\]
+ sky130_fd_sc_hd__dfrtp_1
XFILLER_0_337 VPWR VGND VPWR VGND sky130_ef_sc_hd__decap_12
XFILLER_68_27 VGND VGND VPWR VPWR sky130_fd_sc_hd__fill_1
XFILLER_68_49 VGND VGND VPWR VPWR sky130_fd_sc_hd__fill_1
XFILLER_88_477 VGND VGND VPWR VPWR sky130_fd_sc_hd__fill_1
XFILLER_84_15 VPWR VGND VPWR VGND sky130_ef_sc_hd__decap_12
XTAP_TAPCELL_ROW_39_572 VGND VPWR sky130_fd_sc_hd__tapvpwrvgnd_1
XFILLER_12_433 VGND VGND VPWR VPWR sky130_fd_sc_hd__decap_6
XFILLER_12_477 VPWR VGND VPWR VGND sky130_ef_sc_hd__decap_12
XPHY_EDGE_ROW_89_Left_183 VGND VGND VPWR VPWR sky130_fd_sc_hd__decap_3
XFILLER_39_308 VGND VGND VPWR VPWR sky130_fd_sc_hd__decap_8
Xhold4 startup_reset\[1\] VGND VGND VPWR VPWR net160 sky130_fd_sc_hd__dlygate4sd3_1
XFILLER_66_138 VGND VGND VPWR VPWR sky130_fd_sc_hd__fill_2
XFILLER_35_503 VGND VGND VPWR VPWR sky130_fd_sc_hd__fill_1
XTAP_TAPCELL_ROW_65_818 VGND VPWR sky130_fd_sc_hd__tapvpwrvgnd_1
XFILLER_35_547 VGND VGND VPWR VPWR sky130_fd_sc_hd__decap_8
XFILLER_74_171 VGND VGND VPWR VPWR sky130_fd_sc_hd__fill_1
X_2941_ net86 _1471_ _1472_ VGND VGND VPWR VPWR _0535_ sky130_fd_sc_hd__nor3_1
XTAP_TAPCELL_ROW_73_895 VGND VPWR sky130_fd_sc_hd__tapvpwrvgnd_1
XFILLER_88_3 VPWR VGND VPWR VGND sky130_ef_sc_hd__decap_12
X_2872_ net190 net27 _1437_ VGND VGND VPWR VPWR _0501_ sky130_fd_sc_hd__mux2_1
X_1823_ u_rx_fifo.wr_ptr\[2\] _0870_ VGND VGND VPWR VPWR _0872_ sky130_fd_sc_hd__nor2_1
X_1754_ _0709_ _0816_ _0818_ VGND VGND VPWR VPWR _0819_ sky130_fd_sc_hd__o21ai_1
Xhold426 u_uart_tx.clk_count\[0\] VGND VGND VPWR VPWR net582 sky130_fd_sc_hd__dlygate4sd3_1
Xhold415 u_parser.u_decoder.decoded_checksum_calc\[5\] VGND VGND VPWR VPWR net571
+ sky130_fd_sc_hd__dlygate4sd3_1
Xhold404 u_parser.u_decoder.decoded_checksum_calc\[0\] VGND VGND VPWR VPWR net560
+ sky130_fd_sc_hd__dlygate4sd3_1
Xhold448 u_parser.u_decoder.timeout_count\[6\] VGND VGND VPWR VPWR net604 sky130_fd_sc_hd__dlygate4sd3_1
Xhold459 u_parser.u_decoder.timeout_count\[3\] VGND VGND VPWR VPWR net615 sky130_fd_sc_hd__dlygate4sd3_1
X_3424_ clknet_leaf_60_clk _0257_ net89 VGND VGND VPWR VPWR u_uart_tx.tx_data\[0\]
+ sky130_fd_sc_hd__dfrtp_1
Xhold437 u_uart_tx.clk_count\[14\] VGND VGND VPWR VPWR net593 sky130_fd_sc_hd__dlygate4sd3_1
X_1685_ _0746_ _0748_ _0751_ _0671_ VGND VGND VPWR VPWR _0752_ sky130_fd_sc_hd__a22o_1
X_3355_ clknet_leaf_33_clk _0188_ net133 VGND VGND VPWR VPWR u_parser.u_decoder.ascii_buf\[11\]\[7\]
+ sky130_fd_sc_hd__dfrtp_1
X_2306_ u_tx_fifo.mem\[8\]\[5\] u_tx_fifo.mem\[9\]\[5\] u_tx_fifo.mem\[10\]\[5\] u_tx_fifo.mem\[11\]\[5\]
+ net66 net62 VGND VGND VPWR VPWR _1111_ sky130_fd_sc_hd__mux4_1
X_3286_ clknet_leaf_9_clk _0122_ VGND VGND VPWR VPWR u_rx_fifo.mem\[8\]\[5\] sky130_fd_sc_hd__dfxtp_1
XFILLER_85_447 VGND VGND VPWR VPWR sky130_fd_sc_hd__fill_1
X_2237_ u_parser.u_packet_encoder.byte_index\[0\] u_parser.u_packet_encoder.byte_index\[1\]
+ u_parser.u_packet_encoder.byte_index\[2\] _0881_ VGND VGND VPWR VPWR _1065_ sky130_fd_sc_hd__nand4_1
X_2168_ _1029_ _1043_ VGND VGND VPWR VPWR _1044_ sky130_fd_sc_hd__xor2_1
XFILLER_54_29 VPWR VGND VPWR VGND sky130_ef_sc_hd__decap_12
X_2099_ _0975_ _0976_ VGND VGND VPWR VPWR _0977_ sky130_fd_sc_hd__xnor2_4
XTAP_TAPCELL_ROW_36_542 VGND VPWR sky130_fd_sc_hd__tapvpwrvgnd_1
XFILLER_80_174 VGND VGND VPWR VPWR sky130_fd_sc_hd__decap_4
XTAP_TAPCELL_ROW_0_189 VGND VPWR sky130_fd_sc_hd__tapvpwrvgnd_1
XFILLER_41_517 VGND VGND VPWR VPWR sky130_fd_sc_hd__decap_4
XPHY_EDGE_ROW_17_Right_17 VGND VGND VPWR VPWR sky130_fd_sc_hd__decap_3
XFILLER_5_429 VPWR VGND VPWR VGND sky130_ef_sc_hd__decap_12
XFILLER_79_15 VPWR VGND VPWR VGND sky130_ef_sc_hd__decap_12
XTAP_TAPCELL_ROW_8_278 VGND VPWR sky130_fd_sc_hd__tapvpwrvgnd_1
XFILLER_88_263 VPWR VGND VPWR VGND sky130_ef_sc_hd__decap_12
XPHY_EDGE_ROW_26_Right_26 VGND VGND VPWR VPWR sky130_fd_sc_hd__decap_3
XFILLER_17_514 VGND VGND VPWR VPWR sky130_fd_sc_hd__decap_4
XFILLER_71_163 VGND VGND VPWR VPWR sky130_fd_sc_hd__decap_4
XPHY_EDGE_ROW_35_Right_35 VGND VGND VPWR VPWR sky130_fd_sc_hd__decap_3
XTAP_TAPCELL_ROW_70_865 VGND VPWR sky130_fd_sc_hd__tapvpwrvgnd_1
XPHY_EDGE_ROW_44_Right_44 VGND VGND VPWR VPWR sky130_fd_sc_hd__decap_3
X_3140_ _0705_ _1572_ VGND VGND VPWR VPWR _1575_ sky130_fd_sc_hd__and2b_1
XTAP_TAPCELL_ROW_78_943 VGND VPWR sky130_fd_sc_hd__tapvpwrvgnd_1
X_3071_ u_uart_rx.sample_div_count\[5\] u_uart_rx.sample_div_count\[6\] _1530_ VGND
+ VGND VPWR VPWR _1534_ sky130_fd_sc_hd__and3_1
X_2022_ _0946_ _0951_ VGND VGND VPWR VPWR _0956_ sky130_fd_sc_hd__nor2_4
XFILLER_47_193 VPWR VGND VPWR VGND sky130_ef_sc_hd__decap_12
XFILLER_62_141 VGND VGND VPWR VPWR sky130_fd_sc_hd__fill_2
XFILLER_90_472 VGND VGND VPWR VPWR sky130_fd_sc_hd__decap_4
XTAP_TAPCELL_ROW_33_512 VGND VPWR sky130_fd_sc_hd__tapvpwrvgnd_1
XFILLER_35_377 VGND VGND VPWR VPWR sky130_fd_sc_hd__decap_4
XFILLER_62_152 VGND VGND VPWR VPWR sky130_fd_sc_hd__fill_1
XFILLER_62_174 VGND VGND VPWR VPWR sky130_fd_sc_hd__fill_2
XPHY_EDGE_ROW_53_Right_53 VGND VGND VPWR VPWR sky130_fd_sc_hd__decap_3
X_2924_ net638 _1460_ net6 VGND VGND VPWR VPWR _1463_ sky130_fd_sc_hd__o21ai_1
X_2855_ net154 _0797_ net150 VGND VGND VPWR VPWR _1432_ sky130_fd_sc_hd__a21oi_1
X_1806_ _0858_ _0859_ VGND VGND VPWR VPWR _0860_ sky130_fd_sc_hd__xnor2_1
X_2786_ net597 net43 _1408_ VGND VGND VPWR VPWR _0444_ sky130_fd_sc_hd__mux2_1
Xhold201 u_rx_fifo.mem\[10\]\[3\] VGND VGND VPWR VPWR net357 sky130_fd_sc_hd__dlygate4sd3_1
Xhold212 u_tx_fifo.mem\[9\]\[1\] VGND VGND VPWR VPWR net368 sky130_fd_sc_hd__dlygate4sd3_1
Xhold223 u_tx_fifo.mem\[15\]\[6\] VGND VGND VPWR VPWR net379 sky130_fd_sc_hd__dlygate4sd3_1
Xhold234 u_tx_fifo.mem\[2\]\[1\] VGND VGND VPWR VPWR net390 sky130_fd_sc_hd__dlygate4sd3_1
X_1737_ u_parser.u_decoder.decoded_checksum_rx\[0\] u_parser.u_decoder.decoded_checksum_calc\[0\]
+ VGND VGND VPWR VPWR _0803_ sky130_fd_sc_hd__nand2b_1
Xhold256 u_rx_fifo.mem\[7\]\[6\] VGND VGND VPWR VPWR net412 sky130_fd_sc_hd__dlygate4sd3_1
Xhold267 u_uart_rx.low_count\[22\] VGND VGND VPWR VPWR net423 sky130_fd_sc_hd__dlygate4sd3_1
Xhold278 u_uart_tx.tx_data\[1\] VGND VGND VPWR VPWR net434 sky130_fd_sc_hd__dlygate4sd3_1
Xhold245 u_tx_fifo.mem\[9\]\[0\] VGND VGND VPWR VPWR net401 sky130_fd_sc_hd__dlygate4sd3_1
XPHY_EDGE_ROW_62_Right_62 VGND VGND VPWR VPWR sky130_fd_sc_hd__decap_3
X_1668_ net44 _0726_ _0734_ VGND VGND VPWR VPWR _0735_ sky130_fd_sc_hd__or3b_1
Xhold289 u_uart_rx.low_count\[20\] VGND VGND VPWR VPWR net445 sky130_fd_sc_hd__dlygate4sd3_1
X_3407_ clknet_leaf_50_clk _0240_ net93 VGND VGND VPWR VPWR u_parser.u_packet_encoder.byte_index\[3\]
+ sky130_fd_sc_hd__dfrtp_4
X_1599_ net632 VGND VGND VPWR VPWR _0669_ sky130_fd_sc_hd__inv_2
X_3338_ clknet_leaf_2_clk _0171_ VGND VGND VPWR VPWR u_tx_fifo.mem\[4\]\[6\] sky130_fd_sc_hd__dfxtp_1
XFILLER_58_425 VGND VGND VPWR VPWR sky130_fd_sc_hd__fill_1
XTAP_TAPCELL_ROW_5_248 VGND VPWR sky130_fd_sc_hd__tapvpwrvgnd_1
XFILLER_85_277 VGND VGND VPWR VPWR sky130_fd_sc_hd__decap_3
X_3269_ clknet_leaf_11_clk _0105_ VGND VGND VPWR VPWR u_rx_fifo.mem\[11\]\[4\] sky130_fd_sc_hd__dfxtp_1
XFILLER_65_39 VPWR VGND VPWR VGND sky130_ef_sc_hd__decap_12
XFILLER_38_160 VGND VGND VPWR VPWR sky130_fd_sc_hd__fill_1
XFILLER_26_333 VPWR VGND VPWR VGND sky130_ef_sc_hd__decap_12
XFILLER_81_27 VPWR VGND VPWR VGND sky130_ef_sc_hd__decap_12
XPHY_EDGE_ROW_71_Right_71 VGND VGND VPWR VPWR sky130_fd_sc_hd__decap_3
XPHY_EDGE_ROW_80_Right_80 VGND VGND VPWR VPWR sky130_fd_sc_hd__decap_3
XFILLER_49_458 VGND VGND VPWR VPWR sky130_fd_sc_hd__fill_1
XTAP_TAPCELL_ROW_75_913 VGND VPWR sky130_fd_sc_hd__tapvpwrvgnd_1
XFILLER_91_203 VGND VGND VPWR VPWR sky130_fd_sc_hd__fill_1
XTAP_TAPCELL_ROW_47_648 VGND VPWR sky130_fd_sc_hd__tapvpwrvgnd_1
XTAP_TAPCELL_ROW_83_990 VGND VPWR sky130_fd_sc_hd__tapvpwrvgnd_1
X_2640_ u_parser.u_decoder.ascii_buf\[0\]\[3\] _1324_ _1325_ u_parser.u_decoder.ascii_buf\[0\]\[7\]
+ u_parser.u_decoder.ascii_buf\[0\]\[6\] VGND VGND VPWR VPWR _1327_ sky130_fd_sc_hd__a2111o_1
XTAP_TAPCELL_ROW_10_294 VGND VPWR sky130_fd_sc_hd__tapvpwrvgnd_1
X_2571_ net483 _1273_ net7 VGND VGND VPWR VPWR _0364_ sky130_fd_sc_hd__mux2_1
X_3123_ _1561_ _1562_ VGND VGND VPWR VPWR _0627_ sky130_fd_sc_hd__and2b_1
XTAP_TAPCELL_ROW_2_218 VGND VPWR sky130_fd_sc_hd__tapvpwrvgnd_1
XFILLER_67_255 VGND VGND VPWR VPWR sky130_fd_sc_hd__decap_4
X_3054_ u_uart_rx.sample_div_count\[1\] u_uart_rx.sample_div_count\[0\] _1509_ VGND
+ VGND VPWR VPWR _1522_ sky130_fd_sc_hd__and3_1
XFILLER_27_119 VGND VGND VPWR VPWR sky130_fd_sc_hd__fill_1
X_2005_ net223 net82 _0953_ VGND VGND VPWR VPWR _0118_ sky130_fd_sc_hd__mux2_1
XTAP_TAPCELL_ROW_18_372 VGND VPWR sky130_fd_sc_hd__tapvpwrvgnd_1
XFILLER_50_133 VGND VGND VPWR VPWR sky130_fd_sc_hd__decap_6
X_2907_ _1450_ _1451_ VGND VGND VPWR VPWR _0522_ sky130_fd_sc_hd__nor2_1
XFILLER_31_380 VPWR VGND VPWR VGND sky130_ef_sc_hd__decap_12
XFILLER_50_188 VGND VGND VPWR VPWR sky130_fd_sc_hd__decap_8
X_2838_ _1421_ _1422_ VGND VGND VPWR VPWR _1423_ sky130_fd_sc_hd__xnor2_1
X_2769_ u_parser.u_decoder.ascii_buf\[10\]\[0\] _1394_ _1399_ VGND VGND VPWR VPWR
+ _1400_ sky130_fd_sc_hd__o21ba_1
XTAP_TAPCELL_ROW_92_1079 VGND VPWR sky130_fd_sc_hd__tapvpwrvgnd_1
XFILLER_76_27 VGND VGND VPWR VPWR sky130_fd_sc_hd__fill_1
XFILLER_86_553 VGND VGND VPWR VPWR sky130_fd_sc_hd__fill_2
XFILLER_92_15 VPWR VGND VPWR VGND sky130_ef_sc_hd__decap_12
XFILLER_26_141 VGND VGND VPWR VPWR sky130_fd_sc_hd__fill_1
XTAP_TAPCELL_ROW_44_618 VGND VPWR sky130_fd_sc_hd__tapvpwrvgnd_1
XTAP_TAPCELL_ROW_80_960 VGND VPWR sky130_fd_sc_hd__tapvpwrvgnd_1
XTAP_TAPCELL_ROW_52_695 VGND VPWR sky130_fd_sc_hd__tapvpwrvgnd_1
XFILLER_10_553 VGND VGND VPWR VPWR sky130_fd_sc_hd__fill_2
XFILLER_10_531 VGND VGND VPWR VPWR sky130_fd_sc_hd__fill_1
XFILLER_6_513 VPWR VGND VPWR VGND sky130_ef_sc_hd__decap_12
XFILLER_77_520 VGND VGND VPWR VPWR sky130_fd_sc_hd__decap_8
XFILLER_2_35 VGND VGND VPWR VPWR sky130_fd_sc_hd__fill_1
XFILLER_49_233 VGND VGND VPWR VPWR sky130_fd_sc_hd__fill_2
XFILLER_92_501 VPWR VGND VPWR VGND sky130_ef_sc_hd__decap_12
XFILLER_92_545 VGND VGND VPWR VPWR sky130_fd_sc_hd__decap_8
XFILLER_64_269 VPWR VGND VPWR VGND sky130_ef_sc_hd__decap_12
XTAP_TAPCELL_ROW_15_342 VGND VPWR sky130_fd_sc_hd__tapvpwrvgnd_1
X_3810_ clknet_leaf_61_clk _0627_ net88 VGND VGND VPWR VPWR u_tx_fifo.rd_ptr\[2\]
+ sky130_fd_sc_hd__dfrtp_1
XFILLER_20_306 VGND VGND VPWR VPWR sky130_fd_sc_hd__fill_2
XPHY_EDGE_ROW_25_Left_119 VGND VGND VPWR VPWR sky130_fd_sc_hd__decap_3
XFILLER_60_464 VPWR VGND VPWR VGND sky130_ef_sc_hd__decap_12
X_3741_ clknet_leaf_63_clk _0565_ VGND VGND VPWR VPWR u_tx_fifo.mem\[8\]\[4\] sky130_fd_sc_hd__dfxtp_1
X_3672_ clknet_leaf_64_clk _0499_ VGND VGND VPWR VPWR u_tx_fifo.mem\[9\]\[6\] sky130_fd_sc_hd__dfxtp_1
XFILLER_70_3 VPWR VGND VPWR VGND sky130_ef_sc_hd__decap_12
X_2623_ u_parser.u_decoder.ascii_buf\[1\]\[4\] _1313_ u_parser.u_decoder.ascii_buf\[1\]\[6\]
+ VGND VGND VPWR VPWR _1314_ sky130_fd_sc_hd__or3b_1
X_2554_ _0683_ _1253_ u_parser.u_decoder.ascii_buf\[5\]\[1\] VGND VGND VPWR VPWR _1260_
+ sky130_fd_sc_hd__o21ba_1
X_2485_ net407 _1205_ net10 VGND VGND VPWR VPWR _0346_ sky130_fd_sc_hd__mux2_1
XPHY_EDGE_ROW_34_Left_128 VGND VGND VPWR VPWR sky130_fd_sc_hd__decap_3
XFILLER_68_531 VGND VGND VPWR VPWR sky130_fd_sc_hd__fill_1
XFILLER_68_553 VGND VGND VPWR VPWR sky130_fd_sc_hd__fill_2
X_3106_ _0699_ _1554_ VGND VGND VPWR VPWR _1557_ sky130_fd_sc_hd__nor2_1
XFILLER_55_225 VGND VGND VPWR VPWR sky130_fd_sc_hd__decap_6
X_3037_ u_uart_rx.break_detect _1508_ VGND VGND VPWR VPWR _1511_ sky130_fd_sc_hd__or2_1
XFILLER_23_111 VGND VGND VPWR VPWR sky130_fd_sc_hd__fill_1
XPHY_EDGE_ROW_43_Left_137 VGND VGND VPWR VPWR sky130_fd_sc_hd__decap_3
XFILLER_62_29 VPWR VGND VPWR VGND sky130_ef_sc_hd__decap_12
XFILLER_3_505 VPWR VGND VPWR VGND sky130_ef_sc_hd__decap_12
XFILLER_87_15 VPWR VGND VPWR VGND sky130_ef_sc_hd__decap_12
XPHY_EDGE_ROW_52_Left_146 VGND VGND VPWR VPWR sky130_fd_sc_hd__decap_3
XFILLER_93_309 VPWR VGND VPWR VGND sky130_ef_sc_hd__decap_12
XTAP_TAPCELL_ROW_57_743 VGND VPWR sky130_fd_sc_hd__tapvpwrvgnd_1
XFILLER_74_545 VGND VGND VPWR VPWR sky130_fd_sc_hd__decap_8
XTAP_TAPCELL_ROW_29_478 VGND VPWR sky130_fd_sc_hd__tapvpwrvgnd_1
XFILLER_36_41 VGND VGND VPWR VPWR sky130_fd_sc_hd__decap_4
XPHY_EDGE_ROW_61_Left_155 VGND VGND VPWR VPWR sky130_fd_sc_hd__decap_3
XFILLER_36_85 VGND VGND VPWR VPWR sky130_fd_sc_hd__decap_6
XFILLER_14_188 VGND VGND VPWR VPWR sky130_fd_sc_hd__decap_8
XFILLER_42_497 VGND VGND VPWR VPWR sky130_fd_sc_hd__fill_1
XTAP_TAPCELL_ROW_12_312 VGND VPWR sky130_fd_sc_hd__tapvpwrvgnd_1
XFILLER_6_332 VGND VGND VPWR VPWR sky130_fd_sc_hd__decap_8
XPHY_EDGE_ROW_70_Left_164 VGND VGND VPWR VPWR sky130_fd_sc_hd__decap_3
XFILLER_69_317 VGND VGND VPWR VPWR sky130_fd_sc_hd__fill_2
X_2270_ u_tx_fifo.mem\[8\]\[1\] u_tx_fifo.mem\[9\]\[1\] u_tx_fifo.mem\[10\]\[1\] u_tx_fifo.mem\[11\]\[1\]
+ net67 net63 VGND VGND VPWR VPWR _1079_ sky130_fd_sc_hd__mux4_1
XFILLER_84_309 VGND VGND VPWR VPWR sky130_fd_sc_hd__fill_1
XFILLER_65_501 VGND VGND VPWR VPWR sky130_fd_sc_hd__decap_3
XFILLER_18_494 VGND VGND VPWR VPWR sky130_fd_sc_hd__fill_1
X_1985_ net82 net352 _0949_ VGND VGND VPWR VPWR _0102_ sky130_fd_sc_hd__mux2_1
X_3724_ clknet_leaf_33_clk _0548_ net140 VGND VGND VPWR VPWR u_uart_rx.low_count\[14\]
+ sky130_fd_sc_hd__dfrtp_1
X_3655_ clknet_leaf_59_clk _0482_ net90 VGND VGND VPWR VPWR u_tx_fifo.level\[2\] sky130_fd_sc_hd__dfrtp_1
XFILLER_9_181 VGND VGND VPWR VPWR sky130_fd_sc_hd__decap_4
X_2606_ net500 _1300_ net7 VGND VGND VPWR VPWR _0372_ sky130_fd_sc_hd__mux2_1
X_3586_ clknet_leaf_34_clk _0413_ net133 VGND VGND VPWR VPWR u_parser.u_decoder.ascii_buf\[7\]\[5\]
+ sky130_fd_sc_hd__dfrtp_1
X_2537_ u_parser.u_decoder.ascii_buf\[6\]\[1\] _1240_ VGND VGND VPWR VPWR _1247_ sky130_fd_sc_hd__xnor2_1
X_2468_ net155 _0846_ VGND VGND VPWR VPWR _1191_ sky130_fd_sc_hd__nor2_1
XFILLER_75_309 VPWR VGND VPWR VGND sky130_ef_sc_hd__decap_12
XFILLER_68_383 VGND VGND VPWR VPWR sky130_fd_sc_hd__decap_6
X_2399_ u_parser.u_decoder.state\[2\] u_parser.u_decoder.timeout_count\[18\] _0790_
+ _0791_ _0709_ VGND VGND VPWR VPWR _1145_ sky130_fd_sc_hd__a41o_1
XTAP_TAPCELL_ROW_54_713 VGND VPWR sky130_fd_sc_hd__tapvpwrvgnd_1
XFILLER_71_526 VPWR VGND VPWR VGND sky130_ef_sc_hd__decap_12
XTAP_TAPCELL_ROW_26_448 VGND VPWR sky130_fd_sc_hd__tapvpwrvgnd_1
XFILLER_24_475 VGND VGND VPWR VPWR sky130_fd_sc_hd__fill_1
XTAP_TAPCELL_ROW_62_790 VGND VPWR sky130_fd_sc_hd__tapvpwrvgnd_1
XFILLER_11_169 VGND VGND VPWR VPWR sky130_fd_sc_hd__fill_1
XFILLER_7_129 VGND VGND VPWR VPWR sky130_fd_sc_hd__fill_2
XFILLER_22_21 VGND VGND VPWR VPWR sky130_fd_sc_hd__decap_6
XPHY_EDGE_ROW_5_Left_99 VGND VGND VPWR VPWR sky130_fd_sc_hd__decap_3
XFILLER_0_3 VPWR VGND VPWR VGND sky130_ef_sc_hd__decap_12
XFILLER_78_103 VGND VGND VPWR VPWR sky130_fd_sc_hd__fill_2
XFILLER_66_309 VGND VGND VPWR VPWR sky130_fd_sc_hd__fill_1
XFILLER_86_191 VGND VGND VPWR VPWR sky130_fd_sc_hd__decap_4
XFILLER_19_225 VPWR VGND VPWR VGND sky130_ef_sc_hd__decap_12
XFILLER_47_51 VGND VGND VPWR VPWR sky130_fd_sc_hd__decap_4
XFILLER_74_353 VGND VGND VPWR VPWR sky130_fd_sc_hd__decap_8
XFILLER_42_261 VGND VGND VPWR VPWR sky130_fd_sc_hd__decap_3
X_1770_ u_uart_tx.state\[2\] u_uart_tx.state\[1\] u_uart_tx.state\[0\] VGND VGND VPWR
+ VPWR _0833_ sky130_fd_sc_hd__or3_1
X_3440_ clknet_leaf_26_clk _0004_ net124 VGND VGND VPWR VPWR u_uart_rx.state\[0\]
+ sky130_fd_sc_hd__dfstp_1
X_3371_ clknet_leaf_52_clk _0204_ net93 VGND VGND VPWR VPWR u_parser.u_packet_encoder.tag_latched\[7\]
+ sky130_fd_sc_hd__dfrtp_1
X_2322_ u_tx_fifo.mem\[4\]\[7\] u_tx_fifo.mem\[5\]\[7\] u_tx_fifo.mem\[6\]\[7\] u_tx_fifo.mem\[7\]\[7\]
+ net68 net64 VGND VGND VPWR VPWR _1125_ sky130_fd_sc_hd__mux4_1
XFILLER_33_3 VPWR VGND VPWR VGND sky130_ef_sc_hd__decap_12
X_2253_ net79 net295 _0876_ VGND VGND VPWR VPWR _0252_ sky130_fd_sc_hd__mux2_1
XFILLER_69_169 VGND VGND VPWR VPWR sky130_fd_sc_hd__fill_1
X_2184_ _1025_ _1056_ VGND VGND VPWR VPWR _1057_ sky130_fd_sc_hd__xnor2_1
XFILLER_38_523 VGND VGND VPWR VPWR sky130_fd_sc_hd__decap_8
XFILLER_38_545 VGND VGND VPWR VPWR sky130_fd_sc_hd__decap_8
XTAP_TAPCELL_ROW_68_849 VGND VPWR sky130_fd_sc_hd__tapvpwrvgnd_1
XFILLER_80_323 VPWR VGND VPWR VGND sky130_ef_sc_hd__decap_12
XTAP_TAPCELL_ROW_23_418 VGND VPWR sky130_fd_sc_hd__tapvpwrvgnd_1
XFILLER_33_261 VGND VGND VPWR VPWR sky130_fd_sc_hd__decap_4
XFILLER_40_209 VPWR VGND VPWR VGND sky130_ef_sc_hd__decap_12
XTAP_TAPCELL_ROW_31_495 VGND VPWR sky130_fd_sc_hd__tapvpwrvgnd_1
X_1968_ net177 net24 _0947_ VGND VGND VPWR VPWR _0087_ sky130_fd_sc_hd__mux2_1
X_3707_ clknet_leaf_60_clk _0531_ net91 VGND VGND VPWR VPWR u_uart_tx.clk_count\[14\]
+ sky130_fd_sc_hd__dfrtp_1
X_1899_ u_parser.u_packet_encoder.tag_latched\[12\] _0894_ VGND VGND VPWR VPWR _0925_
+ sky130_fd_sc_hd__and2_1
X_3638_ clknet_leaf_35_clk _0465_ net131 VGND VGND VPWR VPWR u_parser.u_decoder.ascii_buf\[3\]\[1\]
+ sky130_fd_sc_hd__dfrtp_1
X_3569_ clknet_leaf_23_clk _0396_ net117 VGND VGND VPWR VPWR u_parser.u_decoder.ascii_buf\[6\]\[4\]
+ sky130_fd_sc_hd__dfrtp_1
XFILLER_0_305 VGND VGND VPWR VPWR sky130_fd_sc_hd__decap_3
XFILLER_0_349 VPWR VGND VPWR VGND sky130_ef_sc_hd__decap_12
XFILLER_84_27 VGND VGND VPWR VPWR sky130_fd_sc_hd__fill_1
XFILLER_16_217 VGND VGND VPWR VPWR sky130_fd_sc_hd__decap_6
XTAP_TAPCELL_ROW_39_573 VGND VPWR sky130_fd_sc_hd__tapvpwrvgnd_1
XFILLER_71_334 VGND VGND VPWR VPWR sky130_fd_sc_hd__fill_2
XFILLER_24_261 VGND VGND VPWR VPWR sky130_fd_sc_hd__decap_8
XFILLER_71_389 VGND VGND VPWR VPWR sky130_fd_sc_hd__decap_3
XFILLER_12_489 VPWR VGND VPWR VGND sky130_ef_sc_hd__decap_12
XFILLER_58_83 VGND VGND VPWR VPWR sky130_fd_sc_hd__fill_1
Xhold5 u_rx_sync.sync_ff1 VGND VGND VPWR VPWR net161 sky130_fd_sc_hd__dlygate4sd3_1
XTAP_TAPCELL_ROW_65_819 VGND VPWR sky130_fd_sc_hd__tapvpwrvgnd_1
X_2940_ u_uart_rx.low_count\[1\] u_uart_rx.low_count\[0\] _0844_ VGND VGND VPWR VPWR
+ _1472_ sky130_fd_sc_hd__and3_1
XTAP_TAPCELL_ROW_73_896 VGND VPWR sky130_fd_sc_hd__tapvpwrvgnd_1
X_2871_ _0946_ _1435_ VGND VGND VPWR VPWR _1437_ sky130_fd_sc_hd__nor2_4
XFILLER_30_253 VGND VGND VPWR VPWR sky130_fd_sc_hd__decap_3
X_1822_ u_rx_fifo.wr_ptr\[2\] _0870_ VGND VGND VPWR VPWR _0871_ sky130_fd_sc_hd__and2_2
XFILLER_30_297 VGND VGND VPWR VPWR sky130_fd_sc_hd__fill_1
X_1753_ u_parser.u_decoder.state\[0\] _0812_ net155 VGND VGND VPWR VPWR _0818_ sky130_fd_sc_hd__a21oi_1
X_1684_ _0749_ _0750_ net146 VGND VGND VPWR VPWR _0751_ sky130_fd_sc_hd__mux2_1
Xhold416 u_parser.u_packet_encoder.crc_latched\[4\] VGND VGND VPWR VPWR net572 sky130_fd_sc_hd__dlygate4sd3_1
Xhold427 u_parser.u_packet_encoder.tag_latched\[33\] VGND VGND VPWR VPWR net583 sky130_fd_sc_hd__dlygate4sd3_1
Xhold405 u_parser.u_decoder.ascii_buf\[6\]\[6\] VGND VGND VPWR VPWR net561 sky130_fd_sc_hd__dlygate4sd3_1
Xhold438 u_parser.u_decoder.ascii_buf\[7\]\[5\] VGND VGND VPWR VPWR net594 sky130_fd_sc_hd__dlygate4sd3_1
X_3423_ clknet_leaf_19_clk _0256_ VGND VGND VPWR VPWR u_rx_fifo.mem\[15\]\[7\] sky130_fd_sc_hd__dfxtp_1
Xhold449 u_parser.u_decoder.timeout_count\[17\] VGND VGND VPWR VPWR net605 sky130_fd_sc_hd__dlygate4sd3_1
X_3354_ clknet_leaf_33_clk _0187_ net133 VGND VGND VPWR VPWR u_parser.u_decoder.ascii_buf\[11\]\[6\]
+ sky130_fd_sc_hd__dfrtp_1
X_2305_ _1108_ _1109_ net61 VGND VGND VPWR VPWR _1110_ sky130_fd_sc_hd__mux2_1
X_3285_ clknet_leaf_11_clk _0121_ VGND VGND VPWR VPWR u_rx_fifo.mem\[8\]\[4\] sky130_fd_sc_hd__dfxtp_1
X_2236_ u_parser.u_packet_encoder.byte_index\[0\] u_parser.u_packet_encoder.byte_index\[1\]
+ _0881_ u_parser.u_packet_encoder.byte_index\[2\] VGND VGND VPWR VPWR _1064_ sky130_fd_sc_hd__a31o_1
XTAP_TAPCELL_ROW_88_1040 VGND VPWR sky130_fd_sc_hd__tapvpwrvgnd_1
X_2167_ _1036_ _1042_ VGND VGND VPWR VPWR _1043_ sky130_fd_sc_hd__xnor2_1
XFILLER_65_161 VGND VGND VPWR VPWR sky130_fd_sc_hd__fill_1
X_2098_ tag_raw\[27\] _0968_ VGND VGND VPWR VPWR _0976_ sky130_fd_sc_hd__xnor2_2
XTAP_TAPCELL_ROW_36_543 VGND VPWR sky130_fd_sc_hd__tapvpwrvgnd_1
XFILLER_70_29 VPWR VGND VPWR VGND sky130_ef_sc_hd__decap_12
XFILLER_79_27 VGND VGND VPWR VPWR sky130_fd_sc_hd__decap_4
XTAP_TAPCELL_ROW_8_279 VGND VPWR sky130_fd_sc_hd__tapvpwrvgnd_1
XFILLER_0_113 VGND VGND VPWR VPWR sky130_fd_sc_hd__fill_1
XFILLER_88_275 VGND VGND VPWR VPWR sky130_fd_sc_hd__fill_2
XFILLER_76_426 VGND VGND VPWR VPWR sky130_fd_sc_hd__fill_1
XFILLER_48_139 VGND VGND VPWR VPWR sky130_fd_sc_hd__fill_1
XFILLER_29_331 VGND VGND VPWR VPWR sky130_fd_sc_hd__decap_4
XFILLER_44_41 VPWR VGND VPWR VGND sky130_ef_sc_hd__decap_12
XFILLER_12_253 VGND VGND VPWR VPWR sky130_fd_sc_hd__fill_1
XTAP_TAPCELL_ROW_70_866 VGND VPWR sky130_fd_sc_hd__tapvpwrvgnd_1
XFILLER_12_275 VGND VGND VPWR VPWR sky130_fd_sc_hd__fill_1
XFILLER_8_224 VGND VGND VPWR VPWR sky130_fd_sc_hd__decap_8
XFILLER_79_220 VGND VGND VPWR VPWR sky130_fd_sc_hd__decap_4
X_3070_ u_uart_rx.sample_div_count\[5\] _1530_ u_uart_rx.sample_div_count\[6\] VGND
+ VGND VPWR VPWR _1533_ sky130_fd_sc_hd__a21oi_1
XTAP_TAPCELL_ROW_78_944 VGND VPWR sky130_fd_sc_hd__tapvpwrvgnd_1
XFILLER_82_418 VGND VGND VPWR VPWR sky130_fd_sc_hd__fill_2
X_2021_ net29 net258 _0955_ VGND VGND VPWR VPWR _0132_ sky130_fd_sc_hd__mux2_1
XFILLER_82_429 VGND VGND VPWR VPWR sky130_fd_sc_hd__decap_3
XTAP_TAPCELL_ROW_33_513 VGND VPWR sky130_fd_sc_hd__tapvpwrvgnd_1
XFILLER_62_197 VGND VGND VPWR VPWR sky130_fd_sc_hd__decap_3
X_2923_ u_uart_tx.clk_count\[11\] _1460_ VGND VGND VPWR VPWR _1462_ sky130_fd_sc_hd__and2_1
X_2854_ net154 net150 _0797_ VGND VGND VPWR VPWR _1431_ sky130_fd_sc_hd__and3_1
XTAP_TAPCELL_ROW_41_590 VGND VPWR sky130_fd_sc_hd__tapvpwrvgnd_1
X_2785_ u_parser.u_decoder.ascii_buf\[0\]\[3\] net44 _1408_ VGND VGND VPWR VPWR _0443_
+ sky130_fd_sc_hd__mux2_1
X_1805_ u_rx_fifo.level\[2\] _0850_ VGND VGND VPWR VPWR _0859_ sky130_fd_sc_hd__xnor2_1
X_1736_ u_parser.u_decoder.decoded_checksum_calc\[0\] u_parser.u_decoder.decoded_checksum_rx\[0\]
+ VGND VGND VPWR VPWR _0802_ sky130_fd_sc_hd__nand2b_1
Xhold202 u_rx_fifo.mem\[9\]\[6\] VGND VGND VPWR VPWR net358 sky130_fd_sc_hd__dlygate4sd3_1
Xhold213 u_rx_fifo.mem\[3\]\[6\] VGND VGND VPWR VPWR net369 sky130_fd_sc_hd__dlygate4sd3_1
Xhold224 u_rx_fifo.mem\[3\]\[3\] VGND VGND VPWR VPWR net380 sky130_fd_sc_hd__dlygate4sd3_1
Xhold235 u_rx_fifo.mem\[7\]\[5\] VGND VGND VPWR VPWR net391 sky130_fd_sc_hd__dlygate4sd3_1
Xhold257 u_rx_fifo.mem\[2\]\[2\] VGND VGND VPWR VPWR net413 sky130_fd_sc_hd__dlygate4sd3_1
Xhold246 u_tx_fifo.mem\[1\]\[0\] VGND VGND VPWR VPWR net402 sky130_fd_sc_hd__dlygate4sd3_1
Xhold268 u_parser.u_decoder.decoded_payload\[13\] VGND VGND VPWR VPWR net424 sky130_fd_sc_hd__dlygate4sd3_1
X_1667_ _0671_ _0733_ _0728_ _0730_ VGND VGND VPWR VPWR _0734_ sky130_fd_sc_hd__o2bb2a_1
X_1598_ rdm_rx_sync VGND VGND VPWR VPWR _0668_ sky130_fd_sc_hd__inv_2
X_3406_ clknet_leaf_51_clk _0239_ net92 VGND VGND VPWR VPWR u_parser.u_packet_encoder.byte_index\[2\]
+ sky130_fd_sc_hd__dfrtp_4
Xhold279 u_parser.u_decoder.decoded_payload\[24\] VGND VGND VPWR VPWR net435 sky130_fd_sc_hd__dlygate4sd3_1
X_3337_ clknet_leaf_1_clk _0170_ VGND VGND VPWR VPWR u_tx_fifo.mem\[4\]\[5\] sky130_fd_sc_hd__dfxtp_1
XTAP_TAPCELL_ROW_5_249 VGND VPWR sky130_fd_sc_hd__tapvpwrvgnd_1
X_3268_ clknet_leaf_12_clk _0104_ VGND VGND VPWR VPWR u_rx_fifo.mem\[11\]\[3\] sky130_fd_sc_hd__dfxtp_1
X_3199_ clknet_leaf_17_clk _0035_ VGND VGND VPWR VPWR u_rx_fifo.mem\[0\]\[6\] sky130_fd_sc_hd__dfxtp_1
X_2219_ tag_raw\[26\] net558 net56 VGND VGND VPWR VPWR _0223_ sky130_fd_sc_hd__mux2_1
XFILLER_26_378 VPWR VGND VPWR VGND sky130_ef_sc_hd__decap_12
XFILLER_81_39 VGND VGND VPWR VPWR sky130_fd_sc_hd__decap_6
XFILLER_53_197 VGND VGND VPWR VPWR sky130_fd_sc_hd__decap_8
XFILLER_5_205 VGND VGND VPWR VPWR sky130_fd_sc_hd__fill_1
XFILLER_30_65 VGND VGND VPWR VPWR sky130_fd_sc_hd__fill_1
XFILLER_64_407 VGND VGND VPWR VPWR sky130_fd_sc_hd__decap_6
XFILLER_64_429 VGND VGND VPWR VPWR sky130_fd_sc_hd__fill_2
XTAP_TAPCELL_ROW_75_914 VGND VPWR sky130_fd_sc_hd__tapvpwrvgnd_1
XTAP_TAPCELL_ROW_47_649 VGND VPWR sky130_fd_sc_hd__tapvpwrvgnd_1
XFILLER_55_51 VGND VGND VPWR VPWR sky130_fd_sc_hd__decap_4
XFILLER_17_389 VGND VGND VPWR VPWR sky130_fd_sc_hd__decap_3
XTAP_TAPCELL_ROW_83_991 VGND VPWR sky130_fd_sc_hd__tapvpwrvgnd_1
XFILLER_44_197 VGND VGND VPWR VPWR sky130_fd_sc_hd__fill_1
XFILLER_40_392 VGND VGND VPWR VPWR sky130_fd_sc_hd__fill_1
X_2570_ u_parser.u_decoder.ascii_buf\[4\]\[0\] _1272_ _1269_ VGND VGND VPWR VPWR _1273_
+ sky130_fd_sc_hd__o21a_1
XTAP_TAPCELL_ROW_10_295 VGND VPWR sky130_fd_sc_hd__tapvpwrvgnd_1
X_3122_ net67 net63 net49 net60 VGND VGND VPWR VPWR _1562_ sky130_fd_sc_hd__a31o_1
XTAP_TAPCELL_ROW_2_219 VGND VPWR sky130_fd_sc_hd__tapvpwrvgnd_1
X_3053_ _1521_ VGND VGND VPWR VPWR _0598_ sky130_fd_sc_hd__inv_2
XFILLER_67_289 VGND VGND VPWR VPWR sky130_fd_sc_hd__fill_1
XTAP_TAPCELL_ROW_85_1010 VGND VPWR sky130_fd_sc_hd__tapvpwrvgnd_1
X_2004_ net331 net84 _0953_ VGND VGND VPWR VPWR _0117_ sky130_fd_sc_hd__mux2_1
XTAP_TAPCELL_ROW_18_373 VGND VPWR sky130_fd_sc_hd__tapvpwrvgnd_1
XFILLER_35_186 VGND VGND VPWR VPWR sky130_fd_sc_hd__decap_6
XFILLER_50_145 VGND VGND VPWR VPWR sky130_fd_sc_hd__fill_1
X_2906_ net634 _1448_ net6 VGND VGND VPWR VPWR _1451_ sky130_fd_sc_hd__o21ai_1
X_2837_ u_tx_fifo.level\[2\] _1413_ VGND VGND VPWR VPWR _1422_ sky130_fd_sc_hd__xnor2_1
X_2768_ u_parser.u_decoder.ascii_buf\[10\]\[0\] _1398_ VGND VGND VPWR VPWR _1399_
+ sky130_fd_sc_hd__and2_1
X_2699_ u_parser.u_decoder.ascii_buf\[6\]\[1\] net38 _1372_ VGND VGND VPWR VPWR _0393_
+ sky130_fd_sc_hd__mux2_1
X_1719_ u_parser.u_decoder.timeout_count\[1\] u_parser.u_decoder.timeout_count\[0\]
+ u_parser.u_decoder.timeout_count\[2\] VGND VGND VPWR VPWR _0786_ sky130_fd_sc_hd__and3_1
XFILLER_46_429 VGND VGND VPWR VPWR sky130_fd_sc_hd__decap_3
XFILLER_92_27 VGND VGND VPWR VPWR sky130_fd_sc_hd__fill_1
XTAP_TAPCELL_ROW_44_619 VGND VPWR sky130_fd_sc_hd__tapvpwrvgnd_1
XTAP_TAPCELL_ROW_80_961 VGND VPWR sky130_fd_sc_hd__tapvpwrvgnd_1
XFILLER_25_87 VGND VGND VPWR VPWR sky130_fd_sc_hd__fill_1
XTAP_TAPCELL_ROW_52_696 VGND VPWR sky130_fd_sc_hd__tapvpwrvgnd_1
XFILLER_6_525 VGND VGND VPWR VPWR sky130_fd_sc_hd__decap_6
XFILLER_1_241 VGND VGND VPWR VPWR sky130_fd_sc_hd__fill_1
XFILLER_49_223 VGND VGND VPWR VPWR sky130_fd_sc_hd__fill_1
XFILLER_77_554 VGND VGND VPWR VPWR sky130_fd_sc_hd__fill_1
XFILLER_92_513 VPWR VGND VPWR VGND sky130_ef_sc_hd__decap_12
XFILLER_49_278 VGND VGND VPWR VPWR sky130_fd_sc_hd__fill_2
XFILLER_49_289 VGND VGND VPWR VPWR sky130_fd_sc_hd__fill_2
XFILLER_64_259 VGND VGND VPWR VPWR sky130_fd_sc_hd__fill_1
XFILLER_66_83 VGND VGND VPWR VPWR sky130_fd_sc_hd__fill_1
XFILLER_45_440 VGND VGND VPWR VPWR sky130_fd_sc_hd__decap_8
XFILLER_17_186 VGND VGND VPWR VPWR sky130_fd_sc_hd__decap_3
XTAP_TAPCELL_ROW_15_343 VGND VPWR sky130_fd_sc_hd__tapvpwrvgnd_1
X_3740_ clknet_leaf_61_clk _0564_ VGND VGND VPWR VPWR u_tx_fifo.mem\[8\]\[3\] sky130_fd_sc_hd__dfxtp_1
XFILLER_13_381 VGND VGND VPWR VPWR sky130_fd_sc_hd__fill_2
X_3671_ clknet_leaf_64_clk _0498_ VGND VGND VPWR VPWR u_tx_fifo.mem\[9\]\[5\] sky130_fd_sc_hd__dfxtp_1
X_2622_ u_parser.u_decoder.ascii_buf\[1\]\[0\] u_parser.u_decoder.ascii_buf\[1\]\[1\]
+ u_parser.u_decoder.ascii_buf\[1\]\[2\] u_parser.u_decoder.ascii_buf\[1\]\[3\] VGND
+ VGND VPWR VPWR _1313_ sky130_fd_sc_hd__a31o_1
XFILLER_63_3 VPWR VGND VPWR VGND sky130_ef_sc_hd__decap_12
X_2553_ _1253_ u_parser.u_decoder.ascii_buf\[5\]\[1\] u_parser.u_decoder.ascii_buf\[5\]\[0\]
+ VGND VGND VPWR VPWR _1259_ sky130_fd_sc_hd__and3b_1
X_2484_ _1201_ _1204_ VGND VGND VPWR VPWR _1205_ sky130_fd_sc_hd__and2_1
X_3105_ _0699_ _0703_ _1556_ _1554_ u_uart_rx.bit_index\[1\] VGND VGND VPWR VPWR _0615_
+ sky130_fd_sc_hd__a32o_1
X_3036_ u_uart_rx.break_detect _1508_ VGND VGND VPWR VPWR _1510_ sky130_fd_sc_hd__nor2_1
XFILLER_63_270 VGND VGND VPWR VPWR sky130_fd_sc_hd__fill_1
XFILLER_3_517 VPWR VGND VPWR VGND sky130_ef_sc_hd__decap_12
XFILLER_87_27 VPWR VGND VPWR VGND sky130_ef_sc_hd__decap_12
XFILLER_46_237 VPWR VGND VPWR VGND sky130_ef_sc_hd__decap_12
XTAP_TAPCELL_ROW_57_744 VGND VPWR sky130_fd_sc_hd__tapvpwrvgnd_1
XTAP_TAPCELL_ROW_29_479 VGND VPWR sky130_fd_sc_hd__tapvpwrvgnd_1
XFILLER_42_410 VGND VGND VPWR VPWR sky130_fd_sc_hd__fill_1
XFILLER_14_145 VGND VGND VPWR VPWR sky130_fd_sc_hd__decap_8
XFILLER_52_41 VPWR VGND VPWR VGND sky130_ef_sc_hd__decap_12
XTAP_TAPCELL_ROW_12_313 VGND VPWR sky130_fd_sc_hd__tapvpwrvgnd_1
XFILLER_52_85 VPWR VGND VPWR VGND sky130_ef_sc_hd__decap_12
XFILLER_6_300 VGND VGND VPWR VPWR sky130_fd_sc_hd__fill_1
XFILLER_10_373 VGND VGND VPWR VPWR sky130_fd_sc_hd__decap_3
XTAP_TAPCELL_ROW_20_390 VGND VPWR sky130_fd_sc_hd__tapvpwrvgnd_1
XFILLER_69_329 VGND VGND VPWR VPWR sky130_fd_sc_hd__decap_6
XFILLER_92_365 VGND VGND VPWR VPWR sky130_fd_sc_hd__decap_8
XFILLER_92_354 VGND VGND VPWR VPWR sky130_fd_sc_hd__decap_8
XFILLER_80_516 VGND VGND VPWR VPWR sky130_fd_sc_hd__decap_8
XFILLER_18_462 VPWR VGND VPWR VGND sky130_ef_sc_hd__decap_12
XFILLER_92_398 VGND VGND VPWR VPWR sky130_fd_sc_hd__fill_2
XFILLER_93_81 VGND VGND VPWR VPWR sky130_fd_sc_hd__decap_3
XFILLER_45_281 VPWR VGND VPWR VGND sky130_ef_sc_hd__decap_12
X_1984_ net84 net349 _0949_ VGND VGND VPWR VPWR _0101_ sky130_fd_sc_hd__mux2_1
X_3723_ clknet_leaf_30_clk _0547_ net140 VGND VGND VPWR VPWR u_uart_rx.low_count\[13\]
+ sky130_fd_sc_hd__dfrtp_1
X_3654_ clknet_leaf_59_clk _0481_ net90 VGND VGND VPWR VPWR u_tx_fifo.level\[1\] sky130_fd_sc_hd__dfrtp_1
XFILLER_9_193 VGND VGND VPWR VPWR sky130_fd_sc_hd__decap_8
X_2605_ _1296_ _1299_ _0685_ VGND VGND VPWR VPWR _1300_ sky130_fd_sc_hd__mux2_1
X_3585_ clknet_leaf_33_clk _0412_ net133 VGND VGND VPWR VPWR u_parser.u_decoder.ascii_buf\[7\]\[4\]
+ sky130_fd_sc_hd__dfrtp_1
X_2536_ _1239_ u_parser.u_decoder.ascii_buf\[6\]\[1\] u_parser.u_decoder.ascii_buf\[6\]\[0\]
+ VGND VGND VPWR VPWR _1246_ sky130_fd_sc_hd__and3b_1
X_2467_ _1154_ _1189_ _1190_ net564 VGND VGND VPWR VPWR _0343_ sky130_fd_sc_hd__a22o_1
X_2398_ _1142_ _1143_ net526 VGND VGND VPWR VPWR _0320_ sky130_fd_sc_hd__o21a_1
XFILLER_71_505 VGND VGND VPWR VPWR sky130_fd_sc_hd__fill_1
XFILLER_83_387 VGND VGND VPWR VPWR sky130_fd_sc_hd__decap_4
XFILLER_24_421 VGND VGND VPWR VPWR sky130_fd_sc_hd__fill_1
X_3019_ net80 net276 _1506_ VGND VGND VPWR VPWR _0579_ sky130_fd_sc_hd__mux2_1
XTAP_TAPCELL_ROW_54_714 VGND VPWR sky130_fd_sc_hd__tapvpwrvgnd_1
XFILLER_71_538 VPWR VGND VPWR VGND sky130_ef_sc_hd__decap_12
XTAP_TAPCELL_ROW_26_449 VGND VPWR sky130_fd_sc_hd__tapvpwrvgnd_1
XFILLER_24_487 VPWR VGND VPWR VGND sky130_ef_sc_hd__decap_12
XTAP_TAPCELL_ROW_62_791 VGND VPWR sky130_fd_sc_hd__tapvpwrvgnd_1
XFILLER_11_148 VGND VGND VPWR VPWR sky130_fd_sc_hd__fill_2
Xfanout150 u_rx_fifo.rd_ptr\[1\] VGND VGND VPWR VPWR net150 sky130_fd_sc_hd__clkbuf_2
XFILLER_19_237 VGND VGND VPWR VPWR sky130_fd_sc_hd__decap_6
XFILLER_74_321 VPWR VGND VPWR VGND sky130_ef_sc_hd__decap_12
XFILLER_74_365 VPWR VGND VPWR VGND sky130_ef_sc_hd__decap_12
XFILLER_27_281 VGND VGND VPWR VPWR sky130_fd_sc_hd__decap_3
XFILLER_63_51 VGND VGND VPWR VPWR sky130_fd_sc_hd__decap_4
XFILLER_42_284 VGND VGND VPWR VPWR sky130_fd_sc_hd__fill_1
XFILLER_6_141 VGND VGND VPWR VPWR sky130_fd_sc_hd__decap_3
X_3370_ clknet_leaf_57_clk _0203_ net97 VGND VGND VPWR VPWR u_parser.u_packet_encoder.tag_latched\[6\]
+ sky130_fd_sc_hd__dfrtp_1
X_2321_ u_tx_fifo.mem\[0\]\[7\] u_tx_fifo.mem\[1\]\[7\] u_tx_fifo.mem\[2\]\[7\] u_tx_fifo.mem\[3\]\[7\]
+ net69 net65 VGND VGND VPWR VPWR _1124_ sky130_fd_sc_hd__mux4_1
X_2252_ net80 net294 _0876_ VGND VGND VPWR VPWR _0251_ sky130_fd_sc_hd__mux2_1
XFILLER_26_3 VPWR VGND VPWR VGND sky130_ef_sc_hd__decap_12
X_2183_ tag_raw\[5\] _1046_ VGND VGND VPWR VPWR _1056_ sky130_fd_sc_hd__xnor2_1
XFILLER_80_302 VGND VGND VPWR VPWR sky130_fd_sc_hd__decap_6
XFILLER_92_195 VGND VGND VPWR VPWR sky130_fd_sc_hd__fill_1
XFILLER_80_335 VPWR VGND VPWR VGND sky130_ef_sc_hd__decap_12
XTAP_TAPCELL_ROW_23_419 VGND VPWR sky130_fd_sc_hd__tapvpwrvgnd_1
X_3706_ clknet_leaf_60_clk net633 net91 VGND VGND VPWR VPWR u_uart_tx.clk_count\[13\]
+ sky130_fd_sc_hd__dfrtp_1
X_1967_ net329 net25 _0947_ VGND VGND VPWR VPWR _0086_ sky130_fd_sc_hd__mux2_1
X_1898_ u_parser.u_packet_encoder.tag_latched\[20\] _0899_ _0902_ u_parser.u_packet_encoder.tag_latched\[4\]
+ VGND VGND VPWR VPWR _0924_ sky130_fd_sc_hd__a22o_1
XTAP_TAPCELL_ROW_31_496 VGND VPWR sky130_fd_sc_hd__tapvpwrvgnd_1
X_3637_ clknet_leaf_35_clk _0464_ net132 VGND VGND VPWR VPWR u_parser.u_decoder.ascii_buf\[3\]\[0\]
+ sky130_fd_sc_hd__dfrtp_1
X_3568_ clknet_leaf_23_clk _0395_ net117 VGND VGND VPWR VPWR u_parser.u_decoder.ascii_buf\[6\]\[3\]
+ sky130_fd_sc_hd__dfrtp_1
XFILLER_88_424 VGND VGND VPWR VPWR sky130_fd_sc_hd__decap_8
X_2519_ _1231_ _1232_ VGND VGND VPWR VPWR _1233_ sky130_fd_sc_hd__and2_1
XFILLER_68_29 VPWR VGND VPWR VGND sky130_ef_sc_hd__decap_12
X_3499_ clknet_leaf_26_clk _0326_ net122 VGND VGND VPWR VPWR u_parser.u_decoder.timeout_count\[1\]
+ sky130_fd_sc_hd__dfrtp_1
XFILLER_29_524 VPWR VGND VPWR VGND sky130_ef_sc_hd__decap_12
XFILLER_75_129 VGND VGND VPWR VPWR sky130_fd_sc_hd__fill_2
XFILLER_17_11 VGND VGND VPWR VPWR sky130_fd_sc_hd__fill_1
XFILLER_56_365 VGND VGND VPWR VPWR sky130_fd_sc_hd__decap_8
XFILLER_17_55 VGND VGND VPWR VPWR sky130_fd_sc_hd__fill_1
XTAP_TAPCELL_ROW_39_574 VGND VPWR sky130_fd_sc_hd__tapvpwrvgnd_1
XFILLER_24_251 VGND VGND VPWR VPWR sky130_fd_sc_hd__fill_1
XFILLER_71_368 VGND VGND VPWR VPWR sky130_fd_sc_hd__fill_1
XFILLER_79_413 VGND VGND VPWR VPWR sky130_fd_sc_hd__fill_1
XFILLER_79_457 VGND VGND VPWR VPWR sky130_fd_sc_hd__fill_2
XFILLER_79_446 VGND VGND VPWR VPWR sky130_fd_sc_hd__fill_2
Xhold6 u_tx_fifo.mem\[4\]\[5\] VGND VGND VPWR VPWR net162 sky130_fd_sc_hd__dlygate4sd3_1
XFILLER_47_310 VGND VGND VPWR VPWR sky130_fd_sc_hd__decap_6
XFILLER_47_376 VPWR VGND VPWR VGND sky130_ef_sc_hd__decap_12
XFILLER_62_313 VGND VGND VPWR VPWR sky130_fd_sc_hd__fill_1
XTAP_TAPCELL_ROW_73_897 VGND VPWR sky130_fd_sc_hd__tapvpwrvgnd_1
X_2870_ net30 net397 _1436_ VGND VGND VPWR VPWR _0500_ sky130_fd_sc_hd__mux2_1
XFILLER_30_243 VGND VGND VPWR VPWR sky130_fd_sc_hd__decap_8
X_1821_ u_rx_fifo.wr_ptr\[0\] u_rx_fifo.wr_ptr\[1\] _0848_ VGND VGND VPWR VPWR _0870_
+ sky130_fd_sc_hd__and3_1
XFILLER_30_265 VGND VGND VPWR VPWR sky130_fd_sc_hd__decap_8
Xclkbuf_leaf_10_clk clknet_3_4__leaf_clk VGND VGND VPWR VPWR clknet_leaf_10_clk sky130_fd_sc_hd__clkbuf_8
X_1752_ u_parser.u_decoder.state\[0\] _0812_ VGND VGND VPWR VPWR _0817_ sky130_fd_sc_hd__nand2_1
X_1683_ u_rx_fifo.mem\[4\]\[0\] u_rx_fifo.mem\[5\]\[0\] u_rx_fifo.mem\[6\]\[0\] u_rx_fifo.mem\[7\]\[0\]
+ net153 net149 VGND VGND VPWR VPWR _0750_ sky130_fd_sc_hd__mux4_1
Xhold417 u_parser.u_packet_encoder.crc_latched\[2\] VGND VGND VPWR VPWR net573 sky130_fd_sc_hd__dlygate4sd3_1
XFILLER_7_461 VPWR VGND VPWR VGND sky130_ef_sc_hd__decap_12
Xhold406 u_parser.u_decoder.ascii_buf\[7\]\[6\] VGND VGND VPWR VPWR net562 sky130_fd_sc_hd__dlygate4sd3_1
X_3422_ clknet_leaf_21_clk _0255_ VGND VGND VPWR VPWR u_rx_fifo.mem\[15\]\[6\] sky130_fd_sc_hd__dfxtp_1
Xhold428 u_parser.u_decoder.ascii_buf\[7\]\[4\] VGND VGND VPWR VPWR net584 sky130_fd_sc_hd__dlygate4sd3_1
Xhold439 u_parser.u_decoder.ascii_buf\[10\]\[7\] VGND VGND VPWR VPWR net595 sky130_fd_sc_hd__dlygate4sd3_1
X_3353_ clknet_leaf_33_clk _0186_ net133 VGND VGND VPWR VPWR u_parser.u_decoder.ascii_buf\[11\]\[5\]
+ sky130_fd_sc_hd__dfrtp_1
X_2304_ u_tx_fifo.mem\[4\]\[5\] u_tx_fifo.mem\[5\]\[5\] u_tx_fifo.mem\[6\]\[5\] u_tx_fifo.mem\[7\]\[5\]
+ net68 net64 VGND VGND VPWR VPWR _1109_ sky130_fd_sc_hd__mux4_1
X_3284_ clknet_leaf_12_clk _0120_ VGND VGND VPWR VPWR u_rx_fifo.mem\[8\]\[3\] sky130_fd_sc_hd__dfxtp_1
X_2235_ _0879_ _0881_ _0916_ _1063_ u_parser.u_packet_encoder.byte_index\[1\] VGND
+ VGND VPWR VPWR _0238_ sky130_fd_sc_hd__a32o_1
XFILLER_57_129 VGND VGND VPWR VPWR sky130_fd_sc_hd__decap_3
XTAP_TAPCELL_ROW_88_1041 VGND VPWR sky130_fd_sc_hd__tapvpwrvgnd_1
X_2166_ tag_raw\[2\] _1041_ VGND VGND VPWR VPWR _1042_ sky130_fd_sc_hd__xnor2_1
X_2097_ tag_raw\[39\] tag_raw\[33\] VGND VGND VPWR VPWR _0975_ sky130_fd_sc_hd__xnor2_4
XTAP_TAPCELL_ROW_36_544 VGND VPWR sky130_fd_sc_hd__tapvpwrvgnd_1
XFILLER_53_335 VGND VGND VPWR VPWR sky130_fd_sc_hd__fill_1
XFILLER_53_346 VGND VGND VPWR VPWR sky130_fd_sc_hd__decap_8
XFILLER_21_221 VGND VGND VPWR VPWR sky130_fd_sc_hd__decap_3
XPHY_EDGE_ROW_3_Right_3 VGND VGND VPWR VPWR sky130_fd_sc_hd__decap_3
X_2999_ net186 net27 _1504_ VGND VGND VPWR VPWR _0561_ sky130_fd_sc_hd__mux2_1
XFILLER_21_298 VGND VGND VPWR VPWR sky130_fd_sc_hd__fill_1
XFILLER_88_210 VGND VGND VPWR VPWR sky130_fd_sc_hd__fill_1
XFILLER_0_169 VPWR VGND VPWR VGND sky130_ef_sc_hd__decap_12
XFILLER_71_132 VGND VGND VPWR VPWR sky130_fd_sc_hd__fill_1
XFILLER_44_53 VPWR VGND VPWR VGND sky130_ef_sc_hd__decap_12
XFILLER_71_187 VGND VGND VPWR VPWR sky130_fd_sc_hd__fill_2
XTAP_TAPCELL_ROW_70_867 VGND VPWR sky130_fd_sc_hd__tapvpwrvgnd_1
XFILLER_8_214 VGND VGND VPWR VPWR sky130_fd_sc_hd__fill_2
XFILLER_60_41 VPWR VGND VPWR VGND sky130_ef_sc_hd__decap_12
XFILLER_60_85 VGND VGND VPWR VPWR sky130_fd_sc_hd__decap_6
XFILLER_4_475 VGND VGND VPWR VPWR sky130_fd_sc_hd__fill_1
XFILLER_69_61 VGND VGND VPWR VPWR sky130_fd_sc_hd__fill_1
XFILLER_39_107 VGND VGND VPWR VPWR sky130_fd_sc_hd__decap_4
XTAP_TAPCELL_ROW_78_945 VGND VPWR sky130_fd_sc_hd__tapvpwrvgnd_1
XFILLER_67_449 VGND VGND VPWR VPWR sky130_fd_sc_hd__decap_4
Xclkbuf_leaf_59_clk clknet_3_0__leaf_clk VGND VGND VPWR VPWR clknet_leaf_59_clk sky130_fd_sc_hd__clkbuf_8
X_2020_ net19 net342 _0955_ VGND VGND VPWR VPWR _0131_ sky130_fd_sc_hd__mux2_1
XFILLER_75_471 VGND VGND VPWR VPWR sky130_fd_sc_hd__decap_6
X_2922_ _1460_ _1461_ VGND VGND VPWR VPWR _0527_ sky130_fd_sc_hd__nor2_1
XTAP_TAPCELL_ROW_33_514 VGND VPWR sky130_fd_sc_hd__tapvpwrvgnd_1
XFILLER_93_3 VPWR VGND VPWR VGND sky130_ef_sc_hd__decap_12
X_2853_ net154 _0797_ VGND VGND VPWR VPWR _0489_ sky130_fd_sc_hd__xor2_1
XTAP_TAPCELL_ROW_41_591 VGND VPWR sky130_fd_sc_hd__tapvpwrvgnd_1
X_2784_ net626 net36 _1408_ VGND VGND VPWR VPWR _0442_ sky130_fd_sc_hd__mux2_1
X_1804_ _0854_ _0855_ VGND VGND VPWR VPWR _0858_ sky130_fd_sc_hd__nand2_1
X_1735_ u_parser.u_decoder.decoded_checksum_rx\[1\] _0676_ _0799_ _0800_ net155 VGND
+ VGND VPWR VPWR _0801_ sky130_fd_sc_hd__o221a_1
Xhold203 u_rx_fifo.mem\[1\]\[0\] VGND VGND VPWR VPWR net359 sky130_fd_sc_hd__dlygate4sd3_1
Xhold225 u_rx_fifo.mem\[5\]\[3\] VGND VGND VPWR VPWR net381 sky130_fd_sc_hd__dlygate4sd3_1
Xhold214 u_tx_fifo.mem\[7\]\[7\] VGND VGND VPWR VPWR net370 sky130_fd_sc_hd__dlygate4sd3_1
Xhold247 u_rx_fifo.mem\[3\]\[0\] VGND VGND VPWR VPWR net403 sky130_fd_sc_hd__dlygate4sd3_1
X_1666_ _0731_ _0732_ net146 VGND VGND VPWR VPWR _0733_ sky130_fd_sc_hd__mux2_1
Xhold258 u_rx_fifo.mem\[6\]\[3\] VGND VGND VPWR VPWR net414 sky130_fd_sc_hd__dlygate4sd3_1
Xhold236 u_rx_fifo.mem\[11\]\[6\] VGND VGND VPWR VPWR net392 sky130_fd_sc_hd__dlygate4sd3_1
Xhold269 u_parser.u_decoder.ascii_buf\[7\]\[7\] VGND VGND VPWR VPWR net425 sky130_fd_sc_hd__dlygate4sd3_1
X_1597_ net59 VGND VGND VPWR VPWR _0667_ sky130_fd_sc_hd__inv_2
X_3405_ clknet_leaf_59_clk _0238_ net93 VGND VGND VPWR VPWR u_parser.u_packet_encoder.byte_index\[1\]
+ sky130_fd_sc_hd__dfrtp_2
X_3336_ clknet_leaf_1_clk _0169_ VGND VGND VPWR VPWR u_tx_fifo.mem\[4\]\[4\] sky130_fd_sc_hd__dfxtp_1
X_3267_ clknet_leaf_11_clk _0103_ VGND VGND VPWR VPWR u_rx_fifo.mem\[11\]\[2\] sky130_fd_sc_hd__dfxtp_1
X_3198_ clknet_leaf_20_clk _0034_ VGND VGND VPWR VPWR u_rx_fifo.mem\[0\]\[5\] sky130_fd_sc_hd__dfxtp_1
X_2218_ tag_raw\[25\] net513 net55 VGND VGND VPWR VPWR _0222_ sky130_fd_sc_hd__mux2_1
X_2149_ _1025_ _1026_ VGND VGND VPWR VPWR _1027_ sky130_fd_sc_hd__xnor2_1
XFILLER_81_474 VGND VGND VPWR VPWR sky130_fd_sc_hd__decap_4
XFILLER_81_485 VGND VGND VPWR VPWR sky130_fd_sc_hd__fill_1
XFILLER_41_316 VGND VGND VPWR VPWR sky130_fd_sc_hd__decap_3
XFILLER_89_541 VPWR VGND VPWR VGND sky130_ef_sc_hd__decap_12
XTAP_TAPCELL_ROW_75_915 VGND VPWR sky130_fd_sc_hd__tapvpwrvgnd_1
XFILLER_17_357 VPWR VGND VPWR VGND sky130_ef_sc_hd__decap_12
XFILLER_55_63 VGND VGND VPWR VPWR sky130_fd_sc_hd__fill_1
XTAP_TAPCELL_ROW_83_992 VGND VPWR sky130_fd_sc_hd__tapvpwrvgnd_1
XFILLER_13_541 VPWR VGND VPWR VGND sky130_ef_sc_hd__decap_12
XTAP_TAPCELL_ROW_10_296 VGND VPWR sky130_fd_sc_hd__tapvpwrvgnd_1
X_3121_ net66 net60 net62 net49 VGND VGND VPWR VPWR _1561_ sky130_fd_sc_hd__and4_1
X_3052_ _1512_ _1509_ u_uart_rx.sample_div_count\[0\] VGND VGND VPWR VPWR _1521_ sky130_fd_sc_hd__mux2_1
XFILLER_67_279 VGND VGND VPWR VPWR sky130_fd_sc_hd__fill_1
XTAP_TAPCELL_ROW_85_1011 VGND VPWR sky130_fd_sc_hd__tapvpwrvgnd_1
XFILLER_35_110 VGND VGND VPWR VPWR sky130_fd_sc_hd__fill_2
X_2003_ _0886_ _0942_ VGND VGND VPWR VPWR _0953_ sky130_fd_sc_hd__nor2_4
XFILLER_90_260 VGND VGND VPWR VPWR sky130_fd_sc_hd__fill_2
XTAP_TAPCELL_ROW_18_374 VGND VPWR sky130_fd_sc_hd__tapvpwrvgnd_1
X_2905_ u_uart_tx.clk_count\[5\] u_uart_tx.clk_count\[4\] _1446_ VGND VGND VPWR VPWR
+ _1450_ sky130_fd_sc_hd__and3_1
X_2836_ u_tx_fifo.level\[1\] _1413_ _1419_ VGND VGND VPWR VPWR _1421_ sky130_fd_sc_hd__a21o_1
X_2767_ u_parser.u_decoder.ascii_buf\[10\]\[7\] u_parser.u_decoder.ascii_buf\[10\]\[6\]
+ _1395_ _1396_ VGND VGND VPWR VPWR _1398_ sky130_fd_sc_hd__or4_1
X_1718_ u_parser.u_decoder.timeout_count\[3\] u_parser.u_decoder.timeout_count\[4\]
+ VGND VGND VPWR VPWR _0785_ sky130_fd_sc_hd__nand2_1
X_2698_ u_parser.u_decoder.ascii_buf\[6\]\[0\] net40 _1372_ VGND VGND VPWR VPWR _0392_
+ sky130_fd_sc_hd__mux2_1
X_1649_ u_rx_fifo.mem\[4\]\[3\] u_rx_fifo.mem\[5\]\[3\] u_rx_fifo.mem\[6\]\[3\] u_rx_fifo.mem\[7\]\[3\]
+ net153 net149 VGND VGND VPWR VPWR _0716_ sky130_fd_sc_hd__mux4_1
XFILLER_86_533 VPWR VGND VPWR VGND sky130_ef_sc_hd__decap_12
XFILLER_76_29 VPWR VGND VPWR VGND sky130_ef_sc_hd__decap_12
X_3319_ clknet_leaf_15_clk _0155_ VGND VGND VPWR VPWR u_rx_fifo.mem\[4\]\[6\] sky130_fd_sc_hd__dfxtp_1
XFILLER_54_463 VPWR VGND VPWR VGND sky130_ef_sc_hd__decap_12
XFILLER_41_113 VGND VGND VPWR VPWR sky130_fd_sc_hd__decap_8
XTAP_TAPCELL_ROW_80_962 VGND VPWR sky130_fd_sc_hd__tapvpwrvgnd_1
XFILLER_10_533 VPWR VGND VPWR VGND sky130_ef_sc_hd__decap_12
XTAP_TAPCELL_ROW_52_697 VGND VPWR sky130_fd_sc_hd__tapvpwrvgnd_1
XFILLER_41_98 VGND VGND VPWR VPWR sky130_fd_sc_hd__fill_2
XFILLER_89_360 VGND VGND VPWR VPWR sky130_fd_sc_hd__decap_4
XFILLER_2_15 VPWR VGND VPWR VGND sky130_ef_sc_hd__decap_12
XFILLER_92_525 VGND VGND VPWR VPWR sky130_fd_sc_hd__decap_6
XFILLER_17_121 VGND VGND VPWR VPWR sky130_fd_sc_hd__decap_3
XFILLER_45_485 VPWR VGND VPWR VGND sky130_ef_sc_hd__decap_12
XFILLER_82_83 VGND VGND VPWR VPWR sky130_fd_sc_hd__fill_1
XTAP_TAPCELL_ROW_15_344 VGND VPWR sky130_fd_sc_hd__tapvpwrvgnd_1
XFILLER_60_477 VPWR VGND VPWR VGND sky130_ef_sc_hd__decap_12
XFILLER_13_393 VGND VGND VPWR VPWR sky130_fd_sc_hd__decap_3
X_3670_ clknet_leaf_63_clk _0497_ VGND VGND VPWR VPWR u_tx_fifo.mem\[9\]\[4\] sky130_fd_sc_hd__dfxtp_1
X_2621_ u_parser.u_decoder.ascii_buf\[1\]\[0\] _1310_ VGND VGND VPWR VPWR _1312_ sky130_fd_sc_hd__nand2_1
X_2552_ u_parser.u_decoder.ascii_buf\[5\]\[5\] _1255_ _1256_ _1253_ VGND VGND VPWR
+ VPWR _1258_ sky130_fd_sc_hd__a211o_1
XFILLER_56_3 VPWR VGND VPWR VGND sky130_ef_sc_hd__decap_12
X_2483_ u_parser.u_decoder.ascii_buf\[9\]\[0\] u_parser.u_decoder.ascii_buf\[9\]\[1\]
+ _1195_ u_parser.u_decoder.ascii_buf\[9\]\[2\] VGND VGND VPWR VPWR _1204_ sky130_fd_sc_hd__a31o_1
XTAP_TAPCELL_ROW_91_1070 VGND VPWR sky130_fd_sc_hd__tapvpwrvgnd_1
XFILLER_68_533 VPWR VGND VPWR VGND sky130_ef_sc_hd__decap_12
X_3104_ u_uart_rx.bit_index\[1\] u_uart_rx.bit_index\[0\] VGND VGND VPWR VPWR _1556_
+ sky130_fd_sc_hd__or2_1
X_3035_ _0820_ _1508_ VGND VGND VPWR VPWR _1509_ sky130_fd_sc_hd__nand2b_2
XFILLER_36_452 VGND VGND VPWR VPWR sky130_fd_sc_hd__decap_3
XFILLER_51_444 VGND VGND VPWR VPWR sky130_fd_sc_hd__decap_4
X_3799_ clknet_leaf_17_clk _0617_ net121 VGND VGND VPWR VPWR rx_fifo_in_data\[0\]
+ sky130_fd_sc_hd__dfrtp_1
X_2819_ u_parser.u_decoder.ascii_buf\[4\]\[1\] net38 _1412_ VGND VGND VPWR VPWR _0473_
+ sky130_fd_sc_hd__mux2_1
XFILLER_11_57 VGND VGND VPWR VPWR sky130_fd_sc_hd__decap_3
XFILLER_11_35 VGND VGND VPWR VPWR sky130_fd_sc_hd__decap_4
XFILLER_3_529 VPWR VGND VPWR VGND sky130_ef_sc_hd__decap_12
XFILLER_87_39 VGND VGND VPWR VPWR sky130_fd_sc_hd__decap_6
XFILLER_86_330 VGND VGND VPWR VPWR sky130_fd_sc_hd__decap_3
XFILLER_86_363 VGND VGND VPWR VPWR sky130_fd_sc_hd__fill_1
XFILLER_74_514 VGND VGND VPWR VPWR sky130_fd_sc_hd__fill_1
XFILLER_46_249 VGND VGND VPWR VPWR sky130_fd_sc_hd__decap_3
XTAP_TAPCELL_ROW_57_745 VGND VPWR sky130_fd_sc_hd__tapvpwrvgnd_1
XFILLER_27_430 VPWR VGND VPWR VGND sky130_ef_sc_hd__decap_12
XFILLER_27_474 VGND VGND VPWR VPWR sky130_fd_sc_hd__decap_4
XFILLER_27_496 VGND VGND VPWR VPWR sky130_fd_sc_hd__decap_8
XFILLER_42_433 VGND VGND VPWR VPWR sky130_fd_sc_hd__decap_4
XTAP_TAPCELL_ROW_12_314 VGND VPWR sky130_fd_sc_hd__tapvpwrvgnd_1
XFILLER_52_53 VPWR VGND VPWR VGND sky130_ef_sc_hd__decap_12
XFILLER_52_97 VGND VGND VPWR VPWR sky130_fd_sc_hd__decap_4
XFILLER_10_363 VGND VGND VPWR VPWR sky130_fd_sc_hd__fill_1
XFILLER_10_396 VGND VGND VPWR VPWR sky130_fd_sc_hd__decap_4
XTAP_TAPCELL_ROW_20_391 VGND VPWR sky130_fd_sc_hd__tapvpwrvgnd_1
XFILLER_18_474 VGND VGND VPWR VPWR sky130_fd_sc_hd__fill_2
XFILLER_33_422 VGND VGND VPWR VPWR sky130_fd_sc_hd__decap_4
XFILLER_45_293 VGND VGND VPWR VPWR sky130_fd_sc_hd__decap_4
X_1983_ u_rx_fifo.wr_ptr\[2\] _0870_ u_rx_fifo.wr_ptr\[3\] VGND VGND VPWR VPWR _0949_
+ sky130_fd_sc_hd__nand3b_4
X_3722_ clknet_leaf_33_clk net581 net140 VGND VGND VPWR VPWR u_uart_rx.low_count\[12\]
+ sky130_fd_sc_hd__dfrtp_1
X_3653_ clknet_leaf_59_clk _0480_ net90 VGND VGND VPWR VPWR u_tx_fifo.level\[0\] sky130_fd_sc_hd__dfrtp_1
X_2604_ u_parser.u_decoder.ascii_buf\[2\]\[0\] u_parser.u_decoder.ascii_buf\[2\]\[1\]
+ u_parser.u_decoder.ascii_buf\[2\]\[2\] u_parser.u_decoder.ascii_buf\[2\]\[3\] _1298_
+ VGND VGND VPWR VPWR _1299_ sky130_fd_sc_hd__o41a_1
X_3584_ clknet_leaf_34_clk _0411_ net134 VGND VGND VPWR VPWR u_parser.u_decoder.ascii_buf\[7\]\[3\]
+ sky130_fd_sc_hd__dfrtp_1
X_2535_ u_parser.u_decoder.ascii_buf\[6\]\[5\] _1242_ _1243_ _1239_ VGND VGND VPWR
+ VPWR _1245_ sky130_fd_sc_hd__a211o_1
X_2466_ _0674_ _1188_ _1190_ VGND VGND VPWR VPWR _0342_ sky130_fd_sc_hd__a21boi_1
X_2397_ net578 _0744_ _1144_ VGND VGND VPWR VPWR _0319_ sky130_fd_sc_hd__mux2_1
XFILLER_68_363 VGND VGND VPWR VPWR sky130_fd_sc_hd__fill_1
XTAP_TAPCELL_ROW_54_715 VGND VPWR sky130_fd_sc_hd__tapvpwrvgnd_1
X_3018_ net82 net260 _1506_ VGND VGND VPWR VPWR _0578_ sky130_fd_sc_hd__mux2_1
XFILLER_24_477 VGND VGND VPWR VPWR sky130_fd_sc_hd__fill_2
XFILLER_24_499 VGND VGND VPWR VPWR sky130_fd_sc_hd__decap_3
XTAP_TAPCELL_ROW_62_792 VGND VPWR sky130_fd_sc_hd__tapvpwrvgnd_1
XFILLER_7_109 VGND VGND VPWR VPWR sky130_fd_sc_hd__decap_3
Xfanout140 net143 VGND VGND VPWR VPWR net140 sky130_fd_sc_hd__clkbuf_4
XFILLER_93_119 VGND VGND VPWR VPWR sky130_fd_sc_hd__fill_1
Xfanout151 u_rx_fifo.rd_ptr\[0\] VGND VGND VPWR VPWR net151 sky130_fd_sc_hd__buf_6
XFILLER_74_333 VPWR VGND VPWR VGND sky130_ef_sc_hd__decap_12
XFILLER_19_249 VGND VGND VPWR VPWR sky130_fd_sc_hd__decap_4
XFILLER_27_271 VGND VGND VPWR VPWR sky130_fd_sc_hd__decap_8
XFILLER_74_377 VGND VGND VPWR VPWR sky130_fd_sc_hd__fill_1
XFILLER_42_241 VGND VGND VPWR VPWR sky130_fd_sc_hd__fill_1
XFILLER_15_499 VGND VGND VPWR VPWR sky130_fd_sc_hd__decap_4
XFILLER_10_160 VGND VGND VPWR VPWR sky130_fd_sc_hd__fill_1
X_2320_ net495 _1123_ net49 VGND VGND VPWR VPWR _0263_ sky130_fd_sc_hd__mux2_1
XFILLER_69_105 VGND VGND VPWR VPWR sky130_fd_sc_hd__decap_6
X_2251_ net83 net328 _0876_ VGND VGND VPWR VPWR _0250_ sky130_fd_sc_hd__mux2_1
X_2182_ _1055_ net572 net52 VGND VGND VPWR VPWR _0193_ sky130_fd_sc_hd__mux2_1
XFILLER_19_3 VPWR VGND VPWR VGND sky130_ef_sc_hd__decap_12
XFILLER_92_141 VGND VGND VPWR VPWR sky130_fd_sc_hd__decap_6
XFILLER_80_358 VGND VGND VPWR VPWR sky130_fd_sc_hd__decap_6
XFILLER_80_347 VGND VGND VPWR VPWR sky130_fd_sc_hd__decap_8
XFILLER_61_550 VGND VGND VPWR VPWR sky130_fd_sc_hd__decap_4
XFILLER_33_274 VGND VGND VPWR VPWR sky130_fd_sc_hd__decap_6
X_1966_ net293 net28 _0947_ VGND VGND VPWR VPWR _0085_ sky130_fd_sc_hd__mux2_1
X_3705_ clknet_leaf_50_clk _0529_ net92 VGND VGND VPWR VPWR u_uart_tx.clk_count\[12\]
+ sky130_fd_sc_hd__dfrtp_1
X_1897_ net33 net303 _0892_ VGND VGND VPWR VPWR _0040_ sky130_fd_sc_hd__mux2_1
XTAP_TAPCELL_ROW_31_497 VGND VPWR sky130_fd_sc_hd__tapvpwrvgnd_1
X_3636_ clknet_leaf_24_clk _0463_ net118 VGND VGND VPWR VPWR u_parser.u_decoder.ascii_buf\[2\]\[7\]
+ sky130_fd_sc_hd__dfrtp_1
X_3567_ clknet_leaf_38_clk _0394_ net117 VGND VGND VPWR VPWR u_parser.u_decoder.ascii_buf\[6\]\[2\]
+ sky130_fd_sc_hd__dfrtp_1
XFILLER_88_403 VPWR VGND VPWR VGND sky130_ef_sc_hd__decap_12
X_2518_ u_parser.u_decoder.ascii_buf\[7\]\[1\] _1226_ VGND VGND VPWR VPWR _1232_ sky130_fd_sc_hd__xnor2_1
X_3498_ clknet_leaf_26_clk _0325_ net122 VGND VGND VPWR VPWR u_parser.u_decoder.timeout_count\[0\]
+ sky130_fd_sc_hd__dfrtp_1
X_2449_ net3 _1177_ _1178_ VGND VGND VPWR VPWR _0337_ sky130_fd_sc_hd__and3_1
XFILLER_84_29 VPWR VGND VPWR VGND sky130_ef_sc_hd__decap_12
XFILLER_29_536 VPWR VGND VPWR VGND sky130_ef_sc_hd__decap_12
XTAP_TAPCELL_ROW_67_840 VGND VPWR sky130_fd_sc_hd__tapvpwrvgnd_1
XTAP_TAPCELL_ROW_39_575 VGND VPWR sky130_fd_sc_hd__tapvpwrvgnd_1
XPHY_EDGE_ROW_49_Left_143 VGND VGND VPWR VPWR sky130_fd_sc_hd__decap_3
XFILLER_20_491 VGND VGND VPWR VPWR sky130_fd_sc_hd__decap_4
XPHY_EDGE_ROW_58_Left_152 VGND VGND VPWR VPWR sky130_fd_sc_hd__decap_3
XFILLER_58_41 VPWR VGND VPWR VGND sky130_ef_sc_hd__decap_12
Xhold7 u_tx_fifo.mem\[4\]\[6\] VGND VGND VPWR VPWR net163 sky130_fd_sc_hd__dlygate4sd3_1
XFILLER_47_355 VGND VGND VPWR VPWR sky130_fd_sc_hd__fill_1
XFILLER_74_141 VGND VGND VPWR VPWR sky130_fd_sc_hd__fill_1
XFILLER_47_388 VGND VGND VPWR VPWR sky130_fd_sc_hd__decap_4
XFILLER_30_222 VGND VGND VPWR VPWR sky130_fd_sc_hd__fill_1
XPHY_EDGE_ROW_67_Left_161 VGND VGND VPWR VPWR sky130_fd_sc_hd__decap_3
XTAP_TAPCELL_ROW_73_898 VGND VPWR sky130_fd_sc_hd__tapvpwrvgnd_1
X_1820_ _0868_ _0869_ VGND VGND VPWR VPWR _0017_ sky130_fd_sc_hd__nand2_1
X_1751_ u_parser.u_decoder.state\[0\] _0792_ VGND VGND VPWR VPWR _0816_ sky130_fd_sc_hd__and2b_1
X_1682_ u_rx_fifo.mem\[0\]\[0\] u_rx_fifo.mem\[1\]\[0\] u_rx_fifo.mem\[2\]\[0\] u_rx_fifo.mem\[3\]\[0\]
+ net153 net149 VGND VGND VPWR VPWR _0749_ sky130_fd_sc_hd__mux4_1
Xhold418 u_parser.u_packet_encoder.tag_latched\[1\] VGND VGND VPWR VPWR net574 sky130_fd_sc_hd__dlygate4sd3_1
XFILLER_7_473 VPWR VGND VPWR VGND sky130_ef_sc_hd__decap_12
Xhold407 u_parser.u_decoder.ascii_buf\[3\]\[6\] VGND VGND VPWR VPWR net563 sky130_fd_sc_hd__dlygate4sd3_1
X_3421_ clknet_leaf_8_clk _0254_ VGND VGND VPWR VPWR u_rx_fifo.mem\[15\]\[5\] sky130_fd_sc_hd__dfxtp_1
Xhold429 u_parser.u_decoder.ascii_buf\[2\]\[5\] VGND VGND VPWR VPWR net585 sky130_fd_sc_hd__dlygate4sd3_1
X_3352_ clknet_leaf_33_clk _0185_ net133 VGND VGND VPWR VPWR u_parser.u_decoder.ascii_buf\[11\]\[4\]
+ sky130_fd_sc_hd__dfrtp_1
XPHY_EDGE_ROW_76_Left_170 VGND VGND VPWR VPWR sky130_fd_sc_hd__decap_3
X_2303_ u_tx_fifo.mem\[0\]\[5\] u_tx_fifo.mem\[1\]\[5\] u_tx_fifo.mem\[2\]\[5\] u_tx_fifo.mem\[3\]\[5\]
+ net69 net65 VGND VGND VPWR VPWR _1108_ sky130_fd_sc_hd__mux4_1
X_3283_ clknet_leaf_11_clk _0119_ VGND VGND VPWR VPWR u_rx_fifo.mem\[8\]\[2\] sky130_fd_sc_hd__dfxtp_1
X_2234_ _0881_ _1063_ u_parser.u_packet_encoder.byte_index\[0\] VGND VGND VPWR VPWR
+ _0237_ sky130_fd_sc_hd__mux2_1
XTAP_TAPCELL_ROW_88_1042 VGND VPWR sky130_fd_sc_hd__tapvpwrvgnd_1
X_2165_ _1032_ _1040_ VGND VGND VPWR VPWR _1041_ sky130_fd_sc_hd__xnor2_2
XFILLER_93_461 VPWR VGND VPWR VGND sky130_ef_sc_hd__decap_12
XFILLER_26_528 VGND VGND VPWR VPWR sky130_fd_sc_hd__decap_4
XTAP_TAPCELL_ROW_64_810 VGND VPWR sky130_fd_sc_hd__tapvpwrvgnd_1
X_2096_ _0970_ _0973_ VGND VGND VPWR VPWR _0974_ sky130_fd_sc_hd__xnor2_2
XTAP_TAPCELL_ROW_36_545 VGND VPWR sky130_fd_sc_hd__tapvpwrvgnd_1
X_2998_ _0950_ _1435_ VGND VGND VPWR VPWR _1504_ sky130_fd_sc_hd__nor2_4
X_1949_ net81 net387 _0944_ VGND VGND VPWR VPWR _0071_ sky130_fd_sc_hd__mux2_1
X_3619_ clknet_leaf_8_clk _0446_ net115 VGND VGND VPWR VPWR u_parser.u_decoder.ascii_buf\[0\]\[6\]
+ sky130_fd_sc_hd__dfrtp_1
XFILLER_88_288 VGND VGND VPWR VPWR sky130_fd_sc_hd__fill_2
XFILLER_28_77 VGND VGND VPWR VPWR sky130_fd_sc_hd__decap_6
XFILLER_56_185 VGND VGND VPWR VPWR sky130_fd_sc_hd__fill_2
XFILLER_44_65 VPWR VGND VPWR VGND sky130_ef_sc_hd__decap_12
XFILLER_40_553 VGND VGND VPWR VPWR sky130_fd_sc_hd__fill_2
XTAP_TAPCELL_ROW_70_868 VGND VPWR sky130_fd_sc_hd__tapvpwrvgnd_1
XFILLER_5_15 VPWR VGND VPWR VGND sky130_ef_sc_hd__decap_12
XFILLER_4_421 VPWR VGND VPWR VGND sky130_ef_sc_hd__decap_12
XFILLER_79_233 VPWR VGND VPWR VGND sky130_ef_sc_hd__decap_12
XFILLER_69_51 VGND VGND VPWR VPWR sky130_fd_sc_hd__decap_4
XFILLER_67_406 VGND VGND VPWR VPWR sky130_fd_sc_hd__decap_6
XTAP_TAPCELL_ROW_78_946 VGND VPWR sky130_fd_sc_hd__tapvpwrvgnd_1
XTAP_TAPCELL_ROW_7_270 VGND VPWR sky130_fd_sc_hd__tapvpwrvgnd_1
XPHY_EDGE_ROW_13_Right_13 VGND VGND VPWR VPWR sky130_fd_sc_hd__decap_3
X_2921_ net629 _1458_ _1441_ VGND VGND VPWR VPWR _1461_ sky130_fd_sc_hd__o21ai_1
XTAP_TAPCELL_ROW_33_515 VGND VPWR sky130_fd_sc_hd__tapvpwrvgnd_1
XFILLER_86_3 VPWR VGND VPWR VGND sky130_ef_sc_hd__decap_12
X_2852_ _0892_ _1430_ VGND VGND VPWR VPWR _0488_ sky130_fd_sc_hd__nand2_1
X_1803_ _0852_ _0855_ _0856_ _0857_ VGND VGND VPWR VPWR _0012_ sky130_fd_sc_hd__a31o_1
XPHY_EDGE_ROW_22_Right_22 VGND VGND VPWR VPWR sky130_fd_sc_hd__decap_3
XTAP_TAPCELL_ROW_41_592 VGND VPWR sky130_fd_sc_hd__tapvpwrvgnd_1
X_2783_ u_parser.u_decoder.ascii_buf\[0\]\[1\] net38 _1408_ VGND VGND VPWR VPWR _0441_
+ sky130_fd_sc_hd__mux2_1
X_1734_ u_parser.u_decoder.decoded_checksum_rx\[2\] u_parser.u_decoder.decoded_checksum_calc\[2\]
+ VGND VGND VPWR VPWR _0800_ sky130_fd_sc_hd__and2_1
Xhold215 u_rx_fifo.mem\[1\]\[3\] VGND VGND VPWR VPWR net371 sky130_fd_sc_hd__dlygate4sd3_1
Xhold204 u_tx_fifo.mem\[7\]\[1\] VGND VGND VPWR VPWR net360 sky130_fd_sc_hd__dlygate4sd3_1
Xhold226 u_rx_fifo.mem\[7\]\[4\] VGND VGND VPWR VPWR net382 sky130_fd_sc_hd__dlygate4sd3_1
Xhold248 u_rx_fifo.mem\[7\]\[0\] VGND VGND VPWR VPWR net404 sky130_fd_sc_hd__dlygate4sd3_1
Xhold259 u_rx_fifo.mem\[6\]\[7\] VGND VGND VPWR VPWR net415 sky130_fd_sc_hd__dlygate4sd3_1
X_1665_ u_rx_fifo.mem\[4\]\[7\] u_rx_fifo.mem\[5\]\[7\] u_rx_fifo.mem\[6\]\[7\] u_rx_fifo.mem\[7\]\[7\]
+ net154 net149 VGND VGND VPWR VPWR _0732_ sky130_fd_sc_hd__mux4_1
X_3404_ clknet_leaf_59_clk _0237_ net93 VGND VGND VPWR VPWR u_parser.u_packet_encoder.byte_index\[0\]
+ sky130_fd_sc_hd__dfrtp_2
Xhold237 u_rx_fifo.mem\[9\]\[3\] VGND VGND VPWR VPWR net393 sky130_fd_sc_hd__dlygate4sd3_1
X_1596_ u_uart_rx.sample_div_count\[15\] VGND VGND VPWR VPWR _0666_ sky130_fd_sc_hd__inv_2
X_3335_ clknet_leaf_1_clk _0168_ VGND VGND VPWR VPWR u_tx_fifo.mem\[4\]\[3\] sky130_fd_sc_hd__dfxtp_1
XFILLER_85_225 VGND VGND VPWR VPWR sky130_fd_sc_hd__decap_4
XPHY_EDGE_ROW_31_Right_31 VGND VGND VPWR VPWR sky130_fd_sc_hd__decap_3
X_3266_ clknet_leaf_12_clk _0102_ VGND VGND VPWR VPWR u_rx_fifo.mem\[11\]\[1\] sky130_fd_sc_hd__dfxtp_1
X_2217_ net439 net523 net56 VGND VGND VPWR VPWR _0221_ sky130_fd_sc_hd__mux2_1
X_3197_ clknet_leaf_15_clk _0033_ VGND VGND VPWR VPWR u_rx_fifo.mem\[0\]\[4\] sky130_fd_sc_hd__dfxtp_1
X_2148_ tag_raw\[6\] _1003_ VGND VGND VPWR VPWR _1026_ sky130_fd_sc_hd__xnor2_1
XFILLER_38_185 VGND VGND VPWR VPWR sky130_fd_sc_hd__fill_2
XTAP_TAPCELL_ROW_49_670 VGND VPWR sky130_fd_sc_hd__tapvpwrvgnd_1
XFILLER_81_464 VGND VGND VPWR VPWR sky130_fd_sc_hd__fill_1
XFILLER_41_306 VGND VGND VPWR VPWR sky130_fd_sc_hd__fill_1
X_2079_ net155 _0710_ _0782_ VGND VGND VPWR VPWR _0965_ sky130_fd_sc_hd__or3_1
XFILLER_22_531 VGND VGND VPWR VPWR sky130_fd_sc_hd__fill_1
XFILLER_22_553 VGND VGND VPWR VPWR sky130_fd_sc_hd__fill_2
XPHY_EDGE_ROW_40_Right_40 VGND VGND VPWR VPWR sky130_fd_sc_hd__decap_3
XFILLER_14_79 VGND VGND VPWR VPWR sky130_fd_sc_hd__decap_4
XFILLER_89_553 VGND VGND VPWR VPWR sky130_fd_sc_hd__fill_2
XTAP_TAPCELL_ROW_4_240 VGND VPWR sky130_fd_sc_hd__tapvpwrvgnd_1
XTAP_TAPCELL_ROW_75_916 VGND VPWR sky130_fd_sc_hd__tapvpwrvgnd_1
XFILLER_17_369 VPWR VGND VPWR VGND sky130_ef_sc_hd__decap_12
XFILLER_72_453 VGND VGND VPWR VPWR sky130_fd_sc_hd__decap_8
XTAP_TAPCELL_ROW_83_993 VGND VPWR sky130_fd_sc_hd__tapvpwrvgnd_1
XFILLER_72_475 VGND VGND VPWR VPWR sky130_fd_sc_hd__fill_1
XFILLER_72_486 VGND VGND VPWR VPWR sky130_fd_sc_hd__decap_3
XFILLER_72_497 VGND VGND VPWR VPWR sky130_fd_sc_hd__fill_1
XFILLER_13_553 VGND VGND VPWR VPWR sky130_fd_sc_hd__fill_2
XFILLER_25_391 VGND VGND VPWR VPWR sky130_fd_sc_hd__fill_1
XFILLER_40_361 VGND VGND VPWR VPWR sky130_fd_sc_hd__decap_3
XTAP_TAPCELL_ROW_10_297 VGND VPWR sky130_fd_sc_hd__tapvpwrvgnd_1
X_3120_ net62 _1559_ VGND VGND VPWR VPWR _0626_ sky130_fd_sc_hd__xnor2_1
X_3051_ _1513_ _1519_ net422 VGND VGND VPWR VPWR _0597_ sky130_fd_sc_hd__o21a_1
XTAP_TAPCELL_ROW_85_1012 VGND VPWR sky130_fd_sc_hd__tapvpwrvgnd_1
X_2002_ net224 net29 _0952_ VGND VGND VPWR VPWR _0116_ sky130_fd_sc_hd__mux2_1
XFILLER_35_100 VGND VGND VPWR VPWR sky130_fd_sc_hd__fill_1
XFILLER_35_122 VGND VGND VPWR VPWR sky130_fd_sc_hd__fill_1
XFILLER_90_250 VGND VGND VPWR VPWR sky130_fd_sc_hd__fill_2
XFILLER_35_155 VGND VGND VPWR VPWR sky130_fd_sc_hd__decap_4
XTAP_TAPCELL_ROW_46_640 VGND VPWR sky130_fd_sc_hd__tapvpwrvgnd_1
XTAP_TAPCELL_ROW_18_375 VGND VPWR sky130_fd_sc_hd__tapvpwrvgnd_1
X_2904_ _1448_ _1449_ VGND VGND VPWR VPWR _0521_ sky130_fd_sc_hd__nor2_1
X_2835_ net649 _1420_ _1415_ VGND VGND VPWR VPWR _0481_ sky130_fd_sc_hd__mux2_1
X_2766_ u_parser.u_decoder.ascii_buf\[10\]\[7\] u_parser.u_decoder.ascii_buf\[10\]\[6\]
+ _1395_ _1396_ VGND VGND VPWR VPWR _1397_ sky130_fd_sc_hd__nor4_1
X_2697_ _1142_ _1371_ VGND VGND VPWR VPWR _1372_ sky130_fd_sc_hd__nor2_2
X_1717_ _0710_ _0783_ VGND VGND VPWR VPWR _0784_ sky130_fd_sc_hd__nor2_1
X_1648_ u_rx_fifo.mem\[0\]\[3\] u_rx_fifo.mem\[1\]\[3\] u_rx_fifo.mem\[2\]\[3\] u_rx_fifo.mem\[3\]\[3\]
+ net153 net149 VGND VGND VPWR VPWR _0715_ sky130_fd_sc_hd__mux4_1
X_3318_ clknet_leaf_16_clk _0154_ VGND VGND VPWR VPWR u_rx_fifo.mem\[4\]\[5\] sky130_fd_sc_hd__dfxtp_1
XFILLER_86_545 VGND VGND VPWR VPWR sky130_fd_sc_hd__decap_8
XFILLER_58_225 VPWR VGND VPWR VGND sky130_ef_sc_hd__decap_12
X_3249_ clknet_leaf_5_clk _0085_ VGND VGND VPWR VPWR u_tx_fifo.mem\[6\]\[0\] sky130_fd_sc_hd__dfxtp_1
XFILLER_58_269 VPWR VGND VPWR VGND sky130_ef_sc_hd__decap_12
XTAP_TAPCELL_ROW_1_210 VGND VPWR sky130_fd_sc_hd__tapvpwrvgnd_1
XFILLER_92_29 VPWR VGND VPWR VGND sky130_ef_sc_hd__decap_12
XFILLER_14_306 VGND VGND VPWR VPWR sky130_fd_sc_hd__fill_2
XFILLER_54_475 VGND VGND VPWR VPWR sky130_fd_sc_hd__fill_1
XFILLER_54_486 VGND VGND VPWR VPWR sky130_fd_sc_hd__fill_2
XTAP_TAPCELL_ROW_80_963 VGND VPWR sky130_fd_sc_hd__tapvpwrvgnd_1
XFILLER_10_501 VPWR VGND VPWR VGND sky130_ef_sc_hd__decap_12
XFILLER_22_350 VGND VGND VPWR VPWR sky130_fd_sc_hd__fill_1
XFILLER_41_169 VGND VGND VPWR VPWR sky130_fd_sc_hd__decap_6
XFILLER_22_372 VGND VGND VPWR VPWR sky130_fd_sc_hd__decap_4
XTAP_TAPCELL_ROW_52_698 VGND VPWR sky130_fd_sc_hd__tapvpwrvgnd_1
XFILLER_10_545 VGND VGND VPWR VPWR sky130_fd_sc_hd__decap_8
XFILLER_41_55 VGND VGND VPWR VPWR sky130_fd_sc_hd__fill_1
XFILLER_1_265 VGND VGND VPWR VPWR sky130_fd_sc_hd__decap_3
XFILLER_1_254 VGND VGND VPWR VPWR sky130_fd_sc_hd__decap_3
XFILLER_2_27 VGND VGND VPWR VPWR sky130_fd_sc_hd__fill_1
XFILLER_49_225 VGND VGND VPWR VPWR sky130_fd_sc_hd__decap_8
XFILLER_66_41 VGND VGND VPWR VPWR sky130_fd_sc_hd__decap_6
XFILLER_66_85 VGND VGND VPWR VPWR sky130_fd_sc_hd__fill_1
XTAP_TAPCELL_ROW_43_610 VGND VPWR sky130_fd_sc_hd__tapvpwrvgnd_1
XFILLER_45_497 VGND VGND VPWR VPWR sky130_fd_sc_hd__decap_6
XFILLER_72_261 VPWR VGND VPWR VGND sky130_ef_sc_hd__decap_12
XTAP_TAPCELL_ROW_15_345 VGND VPWR sky130_fd_sc_hd__tapvpwrvgnd_1
XFILLER_60_489 VGND VGND VPWR VPWR sky130_fd_sc_hd__decap_4
X_2620_ _1310_ VGND VGND VPWR VPWR _1311_ sky130_fd_sc_hd__inv_2
X_2551_ net466 _1257_ net11 VGND VGND VPWR VPWR _0360_ sky130_fd_sc_hd__mux2_1
X_2482_ net449 _1203_ net10 VGND VGND VPWR VPWR _0345_ sky130_fd_sc_hd__mux2_1
XFILLER_49_3 VPWR VGND VPWR VGND sky130_ef_sc_hd__decap_12
XFILLER_68_501 VPWR VGND VPWR VGND sky130_ef_sc_hd__decap_12
XFILLER_68_545 VGND VGND VPWR VPWR sky130_fd_sc_hd__decap_8
X_3103_ u_uart_rx.bit_index\[1\] u_uart_rx.bit_index\[0\] VGND VGND VPWR VPWR _1555_
+ sky130_fd_sc_hd__nor2_1
X_3034_ u_uart_rx.state\[2\] u_uart_rx.state\[3\] u_uart_rx.state\[4\] VGND VGND VPWR
+ VPWR _1508_ sky130_fd_sc_hd__nor3_1
XFILLER_36_475 VGND VGND VPWR VPWR sky130_fd_sc_hd__fill_1
XFILLER_23_169 VGND VGND VPWR VPWR sky130_fd_sc_hd__decap_3
XFILLER_51_478 VPWR VGND VPWR VGND sky130_ef_sc_hd__decap_12
XPHY_EDGE_ROW_12_Left_106 VGND VGND VPWR VPWR sky130_fd_sc_hd__decap_3
X_3798_ clknet_leaf_27_clk _0616_ net123 VGND VGND VPWR VPWR u_uart_rx.bit_index\[2\]
+ sky130_fd_sc_hd__dfrtp_1
X_2818_ u_parser.u_decoder.ascii_buf\[4\]\[0\] net40 _1412_ VGND VGND VPWR VPWR _0472_
+ sky130_fd_sc_hd__mux2_1
X_2749_ u_parser.u_decoder.ascii_buf\[11\]\[0\] _1383_ VGND VGND VPWR VPWR _1384_
+ sky130_fd_sc_hd__and2_1
XFILLER_11_69 VGND VGND VPWR VPWR sky130_fd_sc_hd__decap_4
XPHY_EDGE_ROW_21_Left_115 VGND VGND VPWR VPWR sky130_fd_sc_hd__decap_3
XFILLER_27_442 VGND VGND VPWR VPWR sky130_fd_sc_hd__decap_6
XFILLER_27_453 VGND VGND VPWR VPWR sky130_fd_sc_hd__fill_1
XTAP_TAPCELL_ROW_57_746 VGND VPWR sky130_fd_sc_hd__tapvpwrvgnd_1
XPHY_EDGE_ROW_30_Left_124 VGND VGND VPWR VPWR sky130_fd_sc_hd__decap_3
XTAP_TAPCELL_ROW_12_315 VGND VPWR sky130_fd_sc_hd__tapvpwrvgnd_1
XFILLER_52_65 VPWR VGND VPWR VGND sky130_ef_sc_hd__decap_12
XFILLER_6_346 VGND VGND VPWR VPWR sky130_fd_sc_hd__fill_1
XTAP_TAPCELL_ROW_20_392 VGND VPWR sky130_fd_sc_hd__tapvpwrvgnd_1
XFILLER_77_51 VGND VGND VPWR VPWR sky130_fd_sc_hd__decap_4
XFILLER_92_389 VGND VGND VPWR VPWR sky130_fd_sc_hd__fill_1
XFILLER_45_250 VGND VGND VPWR VPWR sky130_fd_sc_hd__decap_8
XFILLER_52_209 VGND VGND VPWR VPWR sky130_fd_sc_hd__fill_1
XTAP_TAPCELL_ROW_28_470 VGND VPWR sky130_fd_sc_hd__tapvpwrvgnd_1
X_1982_ net70 net388 _0948_ VGND VGND VPWR VPWR _0100_ sky130_fd_sc_hd__mux2_1
X_3721_ clknet_leaf_33_clk _0545_ net140 VGND VGND VPWR VPWR u_uart_rx.low_count\[11\]
+ sky130_fd_sc_hd__dfrtp_1
X_3652_ clknet_leaf_8_clk _0479_ net116 VGND VGND VPWR VPWR u_parser.u_decoder.ascii_buf\[4\]\[7\]
+ sky130_fd_sc_hd__dfrtp_1
X_2603_ u_parser.u_decoder.ascii_buf\[2\]\[0\] u_parser.u_decoder.ascii_buf\[2\]\[1\]
+ u_parser.u_decoder.ascii_buf\[2\]\[2\] _1297_ VGND VGND VPWR VPWR _1298_ sky130_fd_sc_hd__a31oi_1
X_3583_ clknet_leaf_34_clk _0410_ net134 VGND VGND VPWR VPWR u_parser.u_decoder.ascii_buf\[7\]\[2\]
+ sky130_fd_sc_hd__dfrtp_1
X_2534_ net426 _1244_ net8 VGND VGND VPWR VPWR _0356_ sky130_fd_sc_hd__mux2_1
X_2465_ _1155_ _1189_ _1152_ VGND VGND VPWR VPWR _1190_ sky130_fd_sc_hd__o21ai_1
X_2396_ net577 net35 _1144_ VGND VGND VPWR VPWR _0318_ sky130_fd_sc_hd__mux2_1
XFILLER_56_526 VGND VGND VPWR VPWR sky130_fd_sc_hd__decap_6
XFILLER_36_250 VGND VGND VPWR VPWR sky130_fd_sc_hd__fill_2
XTAP_TAPCELL_ROW_54_716 VGND VPWR sky130_fd_sc_hd__tapvpwrvgnd_1
X_3017_ net84 net283 _1506_ VGND VGND VPWR VPWR _0577_ sky130_fd_sc_hd__mux2_1
XFILLER_51_242 VGND VGND VPWR VPWR sky130_fd_sc_hd__fill_1
XTAP_TAPCELL_ROW_62_793 VGND VPWR sky130_fd_sc_hd__tapvpwrvgnd_1
Xfanout130 net135 VGND VGND VPWR VPWR net130 sky130_fd_sc_hd__buf_2
Xfanout152 u_rx_fifo.rd_ptr\[0\] VGND VGND VPWR VPWR net152 sky130_fd_sc_hd__clkbuf_4
Xfanout141 net143 VGND VGND VPWR VPWR net141 sky130_fd_sc_hd__clkbuf_2
XFILLER_19_217 VGND VGND VPWR VPWR sky130_fd_sc_hd__decap_6
XFILLER_74_345 VGND VGND VPWR VPWR sky130_fd_sc_hd__fill_2
XFILLER_62_518 VGND VGND VPWR VPWR sky130_fd_sc_hd__fill_2
XFILLER_62_529 VGND VGND VPWR VPWR sky130_fd_sc_hd__decap_3
XTAP_TAPCELL_ROW_25_440 VGND VPWR sky130_fd_sc_hd__tapvpwrvgnd_1
XFILLER_42_253 VGND VGND VPWR VPWR sky130_fd_sc_hd__decap_8
XPHY_EDGE_ROW_69_Right_69 VGND VGND VPWR VPWR sky130_fd_sc_hd__decap_3
XFILLER_8_15 VPWR VGND VPWR VGND sky130_ef_sc_hd__decap_12
XPHY_EDGE_ROW_78_Right_78 VGND VGND VPWR VPWR sky130_fd_sc_hd__decap_3
X_2250_ net85 net320 _0876_ VGND VGND VPWR VPWR _0249_ sky130_fd_sc_hd__mux2_1
X_2181_ _1053_ _1054_ VGND VGND VPWR VPWR _1055_ sky130_fd_sc_hd__xnor2_1
XFILLER_38_515 VGND VGND VPWR VPWR sky130_fd_sc_hd__decap_3
XFILLER_65_345 VGND VGND VPWR VPWR sky130_fd_sc_hd__fill_2
XPHY_EDGE_ROW_87_Right_87 VGND VGND VPWR VPWR sky130_fd_sc_hd__decap_3
XFILLER_33_297 VGND VGND VPWR VPWR sky130_fd_sc_hd__fill_1
X_1965_ _0890_ _0946_ VGND VGND VPWR VPWR _0947_ sky130_fd_sc_hd__nor2_4
X_3704_ clknet_leaf_50_clk _0528_ net92 VGND VGND VPWR VPWR u_uart_tx.clk_count\[11\]
+ sky130_fd_sc_hd__dfrtp_1
X_1896_ _0911_ _0920_ _0922_ _0904_ u_parser.u_packet_encoder.crc_latched\[3\] VGND
+ VGND VPWR VPWR _0923_ sky130_fd_sc_hd__o32a_1
XTAP_TAPCELL_ROW_31_498 VGND VPWR sky130_fd_sc_hd__tapvpwrvgnd_1
X_3635_ clknet_leaf_24_clk _0462_ net118 VGND VGND VPWR VPWR u_parser.u_decoder.ascii_buf\[2\]\[6\]
+ sky130_fd_sc_hd__dfrtp_1
X_3566_ clknet_leaf_23_clk _0393_ net117 VGND VGND VPWR VPWR u_parser.u_decoder.ascii_buf\[6\]\[1\]
+ sky130_fd_sc_hd__dfrtp_2
XFILLER_88_415 VGND VGND VPWR VPWR sky130_fd_sc_hd__decap_4
X_2517_ u_parser.u_decoder.ascii_buf\[7\]\[5\] _1228_ _1229_ _1225_ VGND VGND VPWR
+ VPWR _1231_ sky130_fd_sc_hd__a211o_1
X_3497_ clknet_leaf_24_clk _0324_ net119 VGND VGND VPWR VPWR u_parser.u_decoder.index\[3\]
+ sky130_fd_sc_hd__dfrtp_1
X_2448_ u_parser.u_decoder.timeout_count\[12\] u_parser.u_decoder.timeout_count\[11\]
+ _1174_ VGND VGND VPWR VPWR _1178_ sky130_fd_sc_hd__nand3_1
XFILLER_75_109 VGND VGND VPWR VPWR sky130_fd_sc_hd__decap_3
X_2379_ tag_raw\[32\] net420 net18 VGND VGND VPWR VPWR _0305_ sky130_fd_sc_hd__mux2_1
XFILLER_29_548 VGND VGND VPWR VPWR sky130_fd_sc_hd__decap_6
XTAP_TAPCELL_ROW_67_841 VGND VPWR sky130_fd_sc_hd__tapvpwrvgnd_1
XFILLER_83_175 VGND VGND VPWR VPWR sky130_fd_sc_hd__fill_1
XTAP_TAPCELL_ROW_39_576 VGND VPWR sky130_fd_sc_hd__tapvpwrvgnd_1
XFILLER_33_23 VGND VGND VPWR VPWR sky130_fd_sc_hd__fill_1
XFILLER_12_448 VPWR VGND VPWR VGND sky130_ef_sc_hd__decap_12
XFILLER_8_419 VGND VGND VPWR VPWR sky130_fd_sc_hd__fill_1
XTAP_TAPCELL_ROW_22_410 VGND VPWR sky130_fd_sc_hd__tapvpwrvgnd_1
XFILLER_20_470 VGND VGND VPWR VPWR sky130_fd_sc_hd__decap_6
XFILLER_3_113 VGND VGND VPWR VPWR sky130_fd_sc_hd__decap_6
XFILLER_58_53 VGND VGND VPWR VPWR sky130_fd_sc_hd__decap_4
Xhold8 u_tx_fifo.mem\[12\]\[4\] VGND VGND VPWR VPWR net164 sky130_fd_sc_hd__dlygate4sd3_1
XFILLER_58_75 VGND VGND VPWR VPWR sky130_fd_sc_hd__decap_8
XFILLER_47_345 VGND VGND VPWR VPWR sky130_fd_sc_hd__fill_1
XFILLER_74_41 VGND VGND VPWR VPWR sky130_fd_sc_hd__decap_6
XFILLER_74_63 VGND VGND VPWR VPWR sky130_fd_sc_hd__decap_4
XFILLER_15_253 VGND VGND VPWR VPWR sky130_fd_sc_hd__decap_3
XFILLER_43_551 VGND VGND VPWR VPWR sky130_fd_sc_hd__decap_4
XTAP_TAPCELL_ROW_73_899 VGND VPWR sky130_fd_sc_hd__tapvpwrvgnd_1
X_1750_ _0735_ _0795_ _0814_ net40 VGND VGND VPWR VPWR _0815_ sky130_fd_sc_hd__or4b_1
XFILLER_7_441 VGND VGND VPWR VPWR sky130_fd_sc_hd__decap_6
XFILLER_7_485 VPWR VGND VPWR VGND sky130_ef_sc_hd__decap_12
X_1681_ net58 _0747_ u_rx_fifo.rd_ptr\[3\] VGND VGND VPWR VPWR _0748_ sky130_fd_sc_hd__o21a_1
Xhold408 u_parser.u_decoder.timeout_count\[18\] VGND VGND VPWR VPWR net564 sky130_fd_sc_hd__dlygate4sd3_1
Xhold419 u_uart_tx.clk_count\[3\] VGND VGND VPWR VPWR net575 sky130_fd_sc_hd__dlygate4sd3_1
X_3420_ clknet_leaf_9_clk _0253_ VGND VGND VPWR VPWR u_rx_fifo.mem\[15\]\[4\] sky130_fd_sc_hd__dfxtp_1
X_3351_ clknet_leaf_36_clk _0184_ net133 VGND VGND VPWR VPWR u_parser.u_decoder.ascii_buf\[11\]\[3\]
+ sky130_fd_sc_hd__dfrtp_1
X_2302_ net448 _1107_ net50 VGND VGND VPWR VPWR _0261_ sky130_fd_sc_hd__mux2_1
XFILLER_31_3 VPWR VGND VPWR VGND sky130_ef_sc_hd__decap_12
X_3282_ clknet_leaf_12_clk _0118_ VGND VGND VPWR VPWR u_rx_fifo.mem\[8\]\[1\] sky130_fd_sc_hd__dfxtp_1
X_2233_ _0882_ net51 VGND VGND VPWR VPWR _1063_ sky130_fd_sc_hd__and2_1
X_2164_ tag_raw\[10\] _1022_ VGND VGND VPWR VPWR _1040_ sky130_fd_sc_hd__xor2_1
XFILLER_93_473 VGND VGND VPWR VPWR sky130_fd_sc_hd__decap_3
XFILLER_53_315 VGND VGND VPWR VPWR sky130_fd_sc_hd__decap_4
XTAP_TAPCELL_ROW_64_811 VGND VPWR sky130_fd_sc_hd__tapvpwrvgnd_1
XFILLER_65_153 VGND VGND VPWR VPWR sky130_fd_sc_hd__fill_1
X_2095_ _0971_ _0972_ VGND VGND VPWR VPWR _0973_ sky130_fd_sc_hd__xnor2_2
XFILLER_0_93 VPWR VGND VPWR VGND sky130_ef_sc_hd__decap_12
XTAP_TAPCELL_ROW_36_546 VGND VPWR sky130_fd_sc_hd__tapvpwrvgnd_1
X_2997_ _0830_ _1502_ u_uart_tx.bit_index\[2\] VGND VGND VPWR VPWR _0560_ sky130_fd_sc_hd__mux2_1
X_1948_ net83 net298 _0944_ VGND VGND VPWR VPWR _0070_ sky130_fd_sc_hd__mux2_1
X_1879_ net27 net228 _0892_ VGND VGND VPWR VPWR _0037_ sky130_fd_sc_hd__mux2_1
X_3618_ clknet_leaf_22_clk _0445_ net117 VGND VGND VPWR VPWR u_parser.u_decoder.ascii_buf\[0\]\[5\]
+ sky130_fd_sc_hd__dfrtp_1
XFILLER_0_105 VGND VGND VPWR VPWR sky130_fd_sc_hd__decap_6
X_3549_ clknet_leaf_41_clk _0376_ net107 VGND VGND VPWR VPWR u_parser.u_decoder.decoded_payload\[32\]
+ sky130_fd_sc_hd__dfrtp_1
XFILLER_48_109 VPWR VGND VPWR VGND sky130_ef_sc_hd__decap_12
XFILLER_69_481 VPWR VGND VPWR VGND sky130_ef_sc_hd__decap_12
XFILLER_56_197 VGND VGND VPWR VPWR sky130_fd_sc_hd__decap_4
XFILLER_71_167 VGND VGND VPWR VPWR sky130_fd_sc_hd__fill_1
XFILLER_44_77 VGND VGND VPWR VPWR sky130_fd_sc_hd__decap_6
XFILLER_52_392 VPWR VGND VPWR VGND sky130_ef_sc_hd__decap_12
XTAP_TAPCELL_ROW_70_869 VGND VPWR sky130_fd_sc_hd__tapvpwrvgnd_1
XFILLER_5_27 VGND VGND VPWR VPWR sky130_fd_sc_hd__decap_8
XFILLER_4_433 VPWR VGND VPWR VGND sky130_ef_sc_hd__decap_12
XFILLER_4_477 VPWR VGND VPWR VGND sky130_ef_sc_hd__decap_12
XFILLER_79_245 VGND VGND VPWR VPWR sky130_fd_sc_hd__decap_4
XTAP_TAPCELL_ROW_7_271 VGND VPWR sky130_fd_sc_hd__tapvpwrvgnd_1
XTAP_TAPCELL_ROW_78_947 VGND VPWR sky130_fd_sc_hd__tapvpwrvgnd_1
XFILLER_35_359 VGND VGND VPWR VPWR sky130_fd_sc_hd__decap_4
X_2920_ u_uart_tx.clk_count\[10\] u_uart_tx.clk_count\[9\] _1456_ VGND VGND VPWR VPWR
+ _1460_ sky130_fd_sc_hd__and3_1
XTAP_TAPCELL_ROW_33_516 VGND VPWR sky130_fd_sc_hd__tapvpwrvgnd_1
XFILLER_50_307 VGND VGND VPWR VPWR sky130_fd_sc_hd__fill_1
X_2851_ u_tx_fifo.wr_ptr\[3\] _0891_ VGND VGND VPWR VPWR _1430_ sky130_fd_sc_hd__nand2_1
XFILLER_79_3 VPWR VGND VPWR VGND sky130_ef_sc_hd__decap_12
X_1802_ _0658_ _0852_ VGND VGND VPWR VPWR _0857_ sky130_fd_sc_hd__nor2_1
XTAP_TAPCELL_ROW_41_593 VGND VPWR sky130_fd_sc_hd__tapvpwrvgnd_1
X_2782_ u_parser.u_decoder.ascii_buf\[0\]\[0\] net40 _1408_ VGND VGND VPWR VPWR _0440_
+ sky130_fd_sc_hd__mux2_1
X_1733_ u_parser.u_decoder.decoded_checksum_rx\[2\] u_parser.u_decoder.decoded_checksum_calc\[2\]
+ VGND VGND VPWR VPWR _0799_ sky130_fd_sc_hd__nor2_1
Xhold216 u_rx_fifo.mem\[2\]\[1\] VGND VGND VPWR VPWR net372 sky130_fd_sc_hd__dlygate4sd3_1
Xhold205 u_tx_fifo.mem\[9\]\[5\] VGND VGND VPWR VPWR net361 sky130_fd_sc_hd__dlygate4sd3_1
X_1664_ u_rx_fifo.mem\[0\]\[7\] u_rx_fifo.mem\[1\]\[7\] u_rx_fifo.mem\[2\]\[7\] u_rx_fifo.mem\[3\]\[7\]
+ net154 net150 VGND VGND VPWR VPWR _0731_ sky130_fd_sc_hd__mux4_1
Xhold238 u_tx_fifo.mem\[1\]\[5\] VGND VGND VPWR VPWR net394 sky130_fd_sc_hd__dlygate4sd3_1
Xhold249 u_tx_fifo.mem\[14\]\[2\] VGND VGND VPWR VPWR net405 sky130_fd_sc_hd__dlygate4sd3_1
X_3403_ clknet_leaf_54_clk _0236_ net98 VGND VGND VPWR VPWR u_parser.u_packet_encoder.tag_latched\[39\]
+ sky130_fd_sc_hd__dfrtp_1
Xhold227 u_tx_fifo.mem\[1\]\[2\] VGND VGND VPWR VPWR net383 sky130_fd_sc_hd__dlygate4sd3_1
X_1595_ net624 VGND VGND VPWR VPWR _0665_ sky130_fd_sc_hd__inv_2
X_3334_ clknet_leaf_5_clk _0167_ VGND VGND VPWR VPWR u_tx_fifo.mem\[4\]\[2\] sky130_fd_sc_hd__dfxtp_1
X_3265_ clknet_leaf_12_clk _0101_ VGND VGND VPWR VPWR u_rx_fifo.mem\[11\]\[0\] sky130_fd_sc_hd__dfxtp_1
X_2216_ tag_raw\[23\] net484 net53 VGND VGND VPWR VPWR _0220_ sky130_fd_sc_hd__mux2_1
X_3196_ clknet_leaf_14_clk _0032_ VGND VGND VPWR VPWR u_rx_fifo.mem\[0\]\[3\] sky130_fd_sc_hd__dfxtp_1
XFILLER_93_281 VPWR VGND VPWR VGND sky130_ef_sc_hd__decap_12
X_2147_ _0996_ _1024_ VGND VGND VPWR VPWR _1025_ sky130_fd_sc_hd__xnor2_1
XFILLER_26_315 VGND VGND VPWR VPWR sky130_fd_sc_hd__fill_1
XFILLER_38_197 VGND VGND VPWR VPWR sky130_fd_sc_hd__fill_1
XTAP_TAPCELL_ROW_49_671 VGND VPWR sky130_fd_sc_hd__tapvpwrvgnd_1
X_2078_ u_parser.u_decoder.index\[0\] u_parser.u_decoder.index\[1\] VGND VGND VPWR
+ VPWR _0964_ sky130_fd_sc_hd__nand2_2
XFILLER_30_46 VGND VGND VPWR VPWR sky130_fd_sc_hd__decap_6
XFILLER_1_447 VGND VGND VPWR VPWR sky130_fd_sc_hd__fill_1
XTAP_TAPCELL_ROW_4_241 VGND VPWR sky130_fd_sc_hd__tapvpwrvgnd_1
XFILLER_29_142 VGND VGND VPWR VPWR sky130_fd_sc_hd__fill_2
XFILLER_29_153 VGND VGND VPWR VPWR sky130_fd_sc_hd__decap_4
XTAP_TAPCELL_ROW_75_917 VGND VPWR sky130_fd_sc_hd__tapvpwrvgnd_1
XFILLER_29_186 VGND VGND VPWR VPWR sky130_fd_sc_hd__fill_1
XFILLER_57_495 VGND VGND VPWR VPWR sky130_fd_sc_hd__decap_8
XTAP_TAPCELL_ROW_83_994 VGND VPWR sky130_fd_sc_hd__tapvpwrvgnd_1
XFILLER_32_307 VGND VGND VPWR VPWR sky130_fd_sc_hd__fill_1
XFILLER_9_503 VGND VGND VPWR VPWR sky130_fd_sc_hd__fill_1
XTAP_TAPCELL_ROW_10_298 VGND VPWR sky130_fd_sc_hd__tapvpwrvgnd_1
X_3050_ _1520_ u_uart_rx.sample_phase\[3\] _1513_ VGND VGND VPWR VPWR _0596_ sky130_fd_sc_hd__mux2_1
X_2001_ net211 net19 _0952_ VGND VGND VPWR VPWR _0115_ sky130_fd_sc_hd__mux2_1
XTAP_TAPCELL_ROW_85_1013 VGND VPWR sky130_fd_sc_hd__tapvpwrvgnd_1
XFILLER_63_421 VGND VGND VPWR VPWR sky130_fd_sc_hd__fill_2
XTAP_TAPCELL_ROW_46_641 VGND VPWR sky130_fd_sc_hd__tapvpwrvgnd_1
XTAP_TAPCELL_ROW_18_376 VGND VPWR sky130_fd_sc_hd__tapvpwrvgnd_1
X_2903_ net651 _1446_ net6 VGND VGND VPWR VPWR _1449_ sky130_fd_sc_hd__o21ai_1
X_2834_ _1418_ _1419_ VGND VGND VPWR VPWR _1420_ sky130_fd_sc_hd__nor2_1
X_2765_ u_parser.u_decoder.ascii_buf\[10\]\[4\] u_parser.u_decoder.ascii_buf\[10\]\[5\]
+ VGND VGND VPWR VPWR _1396_ sky130_fd_sc_hd__nand2_1
XFILLER_6_70 VGND VGND VPWR VPWR sky130_fd_sc_hd__decap_6
X_2696_ u_parser.u_decoder.index\[0\] u_parser.u_decoder.index\[1\] VGND VGND VPWR
+ VPWR _1371_ sky130_fd_sc_hd__nand2b_2
X_1716_ u_parser.u_decoder.index\[2\] u_parser.u_decoder.index\[3\] _0782_ VGND VGND
+ VPWR VPWR _0783_ sky130_fd_sc_hd__a21o_1
X_1647_ net58 _0713_ u_rx_fifo.rd_ptr\[3\] VGND VGND VPWR VPWR _0714_ sky130_fd_sc_hd__o21a_1
X_3317_ clknet_leaf_13_clk _0153_ VGND VGND VPWR VPWR u_rx_fifo.mem\[4\]\[4\] sky130_fd_sc_hd__dfxtp_1
XFILLER_58_237 VGND VGND VPWR VPWR sky130_fd_sc_hd__decap_4
X_3248_ clknet_leaf_20_clk _0084_ VGND VGND VPWR VPWR u_rx_fifo.mem\[14\]\[7\] sky130_fd_sc_hd__dfxtp_1
XTAP_TAPCELL_ROW_1_211 VGND VPWR sky130_fd_sc_hd__tapvpwrvgnd_1
X_3179_ clknet_leaf_26_clk _0015_ net122 VGND VGND VPWR VPWR u_rx_fifo.level\[4\]
+ sky130_fd_sc_hd__dfrtp_1
XFILLER_25_57 VGND VGND VPWR VPWR sky130_fd_sc_hd__decap_6
XTAP_TAPCELL_ROW_80_964 VGND VPWR sky130_fd_sc_hd__tapvpwrvgnd_1
XFILLER_10_513 VPWR VGND VPWR VGND sky130_ef_sc_hd__decap_12
XTAP_TAPCELL_ROW_52_699 VGND VPWR sky130_fd_sc_hd__tapvpwrvgnd_1
XFILLER_9_3 VPWR VGND VPWR VGND sky130_ef_sc_hd__decap_12
XFILLER_1_222 VGND VGND VPWR VPWR sky130_fd_sc_hd__fill_2
XFILLER_77_535 VGND VGND VPWR VPWR sky130_fd_sc_hd__decap_4
XFILLER_57_281 VGND VGND VPWR VPWR sky130_fd_sc_hd__decap_8
XFILLER_82_41 VPWR VGND VPWR VGND sky130_ef_sc_hd__decap_12
XFILLER_17_167 VGND VGND VPWR VPWR sky130_fd_sc_hd__fill_1
XFILLER_72_273 VGND VGND VPWR VPWR sky130_fd_sc_hd__decap_6
XTAP_TAPCELL_ROW_43_611 VGND VPWR sky130_fd_sc_hd__tapvpwrvgnd_1
XTAP_TAPCELL_ROW_15_346 VGND VPWR sky130_fd_sc_hd__tapvpwrvgnd_1
XFILLER_60_457 VGND VGND VPWR VPWR sky130_fd_sc_hd__fill_1
X_2550_ _1253_ _1256_ _0683_ VGND VGND VPWR VPWR _1257_ sky130_fd_sc_hd__mux2_1
X_2481_ _1201_ _1202_ VGND VGND VPWR VPWR _1203_ sky130_fd_sc_hd__and2_1
XFILLER_68_513 VPWR VGND VPWR VGND sky130_ef_sc_hd__decap_12
X_3102_ _0703_ _1554_ u_uart_rx.bit_index\[0\] VGND VGND VPWR VPWR _0614_ sky130_fd_sc_hd__mux2_1
X_3033_ net339 net70 _1507_ VGND VGND VPWR VPWR _0592_ sky130_fd_sc_hd__mux2_1
XFILLER_51_402 VPWR VGND VPWR VGND sky130_ef_sc_hd__decap_12
XFILLER_23_159 VGND VGND VPWR VPWR sky130_fd_sc_hd__fill_1
XFILLER_51_468 VGND VGND VPWR VPWR sky130_fd_sc_hd__fill_2
X_3797_ clknet_leaf_18_clk _0615_ net123 VGND VGND VPWR VPWR u_uart_rx.bit_index\[1\]
+ sky130_fd_sc_hd__dfrtp_2
X_2817_ _0813_ _1142_ VGND VGND VPWR VPWR _1412_ sky130_fd_sc_hd__nor2_2
X_2748_ u_parser.u_decoder.ascii_buf\[11\]\[7\] u_parser.u_decoder.ascii_buf\[11\]\[6\]
+ _1380_ _1381_ VGND VGND VPWR VPWR _1383_ sky130_fd_sc_hd__or4_1
X_2679_ _1332_ _1357_ VGND VGND VPWR VPWR _1358_ sky130_fd_sc_hd__xnor2_1
XFILLER_59_502 VGND VGND VPWR VPWR sky130_fd_sc_hd__fill_2
XFILLER_59_513 VPWR VGND VPWR VGND sky130_ef_sc_hd__decap_12
XFILLER_86_365 VGND VGND VPWR VPWR sky130_fd_sc_hd__fill_2
XFILLER_36_45 VGND VGND VPWR VPWR sky130_fd_sc_hd__fill_1
XFILLER_39_281 VPWR VGND VPWR VGND sky130_ef_sc_hd__decap_12
XTAP_TAPCELL_ROW_57_747 VGND VPWR sky130_fd_sc_hd__tapvpwrvgnd_1
XFILLER_36_78 VGND VGND VPWR VPWR sky130_fd_sc_hd__decap_6
XFILLER_54_262 VGND VGND VPWR VPWR sky130_fd_sc_hd__decap_4
XFILLER_14_115 VGND VGND VPWR VPWR sky130_fd_sc_hd__decap_4
XFILLER_54_295 VGND VGND VPWR VPWR sky130_fd_sc_hd__fill_2
XTAP_TAPCELL_ROW_12_316 VGND VPWR sky130_fd_sc_hd__tapvpwrvgnd_1
XFILLER_10_321 VGND VGND VPWR VPWR sky130_fd_sc_hd__decap_6
XFILLER_52_77 VGND VGND VPWR VPWR sky130_fd_sc_hd__decap_6
XFILLER_10_365 VGND VGND VPWR VPWR sky130_fd_sc_hd__decap_8
XTAP_TAPCELL_ROW_20_393 VGND VPWR sky130_fd_sc_hd__tapvpwrvgnd_1
XFILLER_2_531 VGND VGND VPWR VPWR sky130_fd_sc_hd__fill_1
XFILLER_2_553 VGND VGND VPWR VPWR sky130_fd_sc_hd__fill_2
XFILLER_65_505 VGND VGND VPWR VPWR sky130_fd_sc_hd__decap_6
XFILLER_18_443 VGND VGND VPWR VPWR sky130_fd_sc_hd__decap_4
XFILLER_18_421 VPWR VGND VPWR VGND sky130_ef_sc_hd__decap_12
XTAP_TAPCELL_ROW_28_471 VGND VPWR sky130_fd_sc_hd__tapvpwrvgnd_1
XFILLER_33_446 VGND VGND VPWR VPWR sky130_fd_sc_hd__fill_2
XFILLER_33_457 VPWR VGND VPWR VGND sky130_ef_sc_hd__decap_12
X_1981_ net72 net369 _0948_ VGND VGND VPWR VPWR _0099_ sky130_fd_sc_hd__mux2_1
X_3720_ clknet_leaf_33_clk _0544_ net140 VGND VGND VPWR VPWR u_uart_rx.low_count\[10\]
+ sky130_fd_sc_hd__dfrtp_1
Xclkbuf_leaf_40_clk clknet_3_3__leaf_clk VGND VGND VPWR VPWR clknet_leaf_40_clk sky130_fd_sc_hd__clkbuf_8
X_3651_ clknet_leaf_8_clk _0478_ net116 VGND VGND VPWR VPWR u_parser.u_decoder.ascii_buf\[4\]\[6\]
+ sky130_fd_sc_hd__dfrtp_1
XFILLER_61_3 VPWR VGND VPWR VGND sky130_ef_sc_hd__decap_12
X_3582_ clknet_leaf_34_clk _0409_ net134 VGND VGND VPWR VPWR u_parser.u_decoder.ascii_buf\[7\]\[1\]
+ sky130_fd_sc_hd__dfrtp_2
X_2602_ u_parser.u_decoder.ascii_buf\[2\]\[3\] u_parser.u_decoder.ascii_buf\[2\]\[4\]
+ u_parser.u_decoder.ascii_buf\[2\]\[7\] u_parser.u_decoder.ascii_buf\[2\]\[6\] VGND
+ VGND VPWR VPWR _1297_ sky130_fd_sc_hd__or4b_1
X_2533_ u_parser.u_decoder.ascii_buf\[6\]\[0\] _1243_ _1240_ VGND VGND VPWR VPWR _1244_
+ sky130_fd_sc_hd__o21a_1
XFILLER_5_391 VGND VGND VPWR VPWR sky130_fd_sc_hd__fill_1
X_2464_ u_parser.u_decoder.timeout_count\[14\] _0791_ _1163_ _1181_ VGND VGND VPWR
+ VPWR _1189_ sky130_fd_sc_hd__and4_1
X_2395_ net554 net43 _1144_ VGND VGND VPWR VPWR _0317_ sky130_fd_sc_hd__mux2_1
XFILLER_36_262 VGND VGND VPWR VPWR sky130_fd_sc_hd__fill_1
XTAP_TAPCELL_ROW_54_717 VGND VPWR sky130_fd_sc_hd__tapvpwrvgnd_1
X_3016_ _0868_ _0942_ VGND VGND VPWR VPWR _1506_ sky130_fd_sc_hd__or2_4
XFILLER_51_276 VGND VGND VPWR VPWR sky130_fd_sc_hd__decap_4
XTAP_TAPCELL_ROW_62_794 VGND VPWR sky130_fd_sc_hd__tapvpwrvgnd_1
Xclkbuf_leaf_31_clk clknet_3_7__leaf_clk VGND VGND VPWR VPWR clknet_leaf_31_clk sky130_fd_sc_hd__clkbuf_8
XFILLER_3_328 VGND VGND VPWR VPWR sky130_fd_sc_hd__fill_2
Xfanout131 net135 VGND VGND VPWR VPWR net131 sky130_fd_sc_hd__clkbuf_4
Xfanout120 net126 VGND VGND VPWR VPWR net120 sky130_fd_sc_hd__clkbuf_4
Xfanout142 net143 VGND VGND VPWR VPWR net142 sky130_fd_sc_hd__clkbuf_4
XFILLER_47_505 VGND VGND VPWR VPWR sky130_fd_sc_hd__fill_1
Xfanout153 u_rx_fifo.rd_ptr\[0\] VGND VGND VPWR VPWR net153 sky130_fd_sc_hd__buf_6
XFILLER_86_173 VGND VGND VPWR VPWR sky130_fd_sc_hd__fill_1
XFILLER_47_55 VGND VGND VPWR VPWR sky130_fd_sc_hd__fill_1
XFILLER_86_195 VGND VGND VPWR VPWR sky130_fd_sc_hd__fill_1
XFILLER_15_446 VGND VGND VPWR VPWR sky130_fd_sc_hd__fill_2
XTAP_TAPCELL_ROW_25_441 VGND VPWR sky130_fd_sc_hd__tapvpwrvgnd_1
XFILLER_8_27 VGND VGND VPWR VPWR sky130_fd_sc_hd__fill_1
Xclkbuf_leaf_22_clk clknet_3_4__leaf_clk VGND VGND VPWR VPWR clknet_leaf_22_clk sky130_fd_sc_hd__clkbuf_8
XFILLER_10_195 VGND VGND VPWR VPWR sky130_fd_sc_hd__fill_1
XFILLER_6_133 VGND VGND VPWR VPWR sky130_fd_sc_hd__fill_1
XFILLER_6_111 VGND VGND VPWR VPWR sky130_fd_sc_hd__decap_4
X_2180_ _1035_ _1042_ VGND VGND VPWR VPWR _1054_ sky130_fd_sc_hd__xnor2_1
X_1964_ _0882_ u_tx_fifo.wr_ptr\[0\] u_tx_fifo.wr_ptr\[1\] VGND VGND VPWR VPWR _0946_
+ sky130_fd_sc_hd__or3b_4
Xclkbuf_leaf_13_clk clknet_3_5__leaf_clk VGND VGND VPWR VPWR clknet_leaf_13_clk sky130_fd_sc_hd__clkbuf_8
X_3703_ clknet_leaf_50_clk _0527_ net92 VGND VGND VPWR VPWR u_uart_tx.clk_count\[10\]
+ sky130_fd_sc_hd__dfrtp_1
XTAP_TAPCELL_ROW_31_499 VGND VPWR sky130_fd_sc_hd__tapvpwrvgnd_1
X_1895_ u_parser.u_packet_encoder.tag_latched\[35\] _0896_ _0900_ u_parser.u_packet_encoder.tag_latched\[27\]
+ _0921_ VGND VGND VPWR VPWR _0922_ sky130_fd_sc_hd__a221o_1
X_3634_ clknet_leaf_21_clk _0461_ net118 VGND VGND VPWR VPWR u_parser.u_decoder.ascii_buf\[2\]\[5\]
+ sky130_fd_sc_hd__dfrtp_1
X_3565_ clknet_leaf_38_clk _0392_ net119 VGND VGND VPWR VPWR u_parser.u_decoder.ascii_buf\[6\]\[0\]
+ sky130_fd_sc_hd__dfrtp_1
XFILLER_0_309 VPWR VGND VPWR VGND sky130_ef_sc_hd__decap_12
X_2516_ net438 _1230_ net10 VGND VGND VPWR VPWR _0352_ sky130_fd_sc_hd__mux2_1
X_3496_ clknet_leaf_24_clk _0323_ net118 VGND VGND VPWR VPWR u_parser.u_decoder.index\[2\]
+ sky130_fd_sc_hd__dfrtp_2
X_2447_ u_parser.u_decoder.timeout_count\[11\] u_parser.u_decoder.timeout_count\[10\]
+ _1172_ u_parser.u_decoder.timeout_count\[12\] VGND VGND VPWR VPWR _1177_ sky130_fd_sc_hd__a31o_1
X_2378_ tag_raw\[31\] net486 net15 VGND VGND VPWR VPWR _0304_ sky130_fd_sc_hd__mux2_1
XFILLER_83_110 VGND VGND VPWR VPWR sky130_fd_sc_hd__fill_2
XTAP_TAPCELL_ROW_67_842 VGND VPWR sky130_fd_sc_hd__tapvpwrvgnd_1
XFILLER_64_390 VGND VGND VPWR VPWR sky130_fd_sc_hd__fill_1
XTAP_TAPCELL_ROW_22_411 VGND VPWR sky130_fd_sc_hd__tapvpwrvgnd_1
XFILLER_79_449 VGND VGND VPWR VPWR sky130_fd_sc_hd__decap_8
XFILLER_79_438 VGND VGND VPWR VPWR sky130_fd_sc_hd__decap_8
Xhold9 u_rx_fifo.mem\[13\]\[2\] VGND VGND VPWR VPWR net165 sky130_fd_sc_hd__dlygate4sd3_1
XFILLER_62_305 VGND VGND VPWR VPWR sky130_fd_sc_hd__decap_3
XFILLER_55_390 VGND VGND VPWR VPWR sky130_fd_sc_hd__fill_2
XFILLER_90_41 VPWR VGND VPWR VGND sky130_ef_sc_hd__decap_12
XFILLER_90_85 VGND VGND VPWR VPWR sky130_fd_sc_hd__decap_3
XFILLER_23_90 VGND VGND VPWR VPWR sky130_fd_sc_hd__decap_6
X_1680_ u_rx_fifo.mem\[12\]\[0\] u_rx_fifo.mem\[13\]\[0\] u_rx_fifo.mem\[14\]\[0\]
+ u_rx_fifo.mem\[15\]\[0\] net152 net148 VGND VGND VPWR VPWR _0747_ sky130_fd_sc_hd__mux4_1
Xhold409 u_uart_rx.low_count\[11\] VGND VGND VPWR VPWR net565 sky130_fd_sc_hd__dlygate4sd3_1
XFILLER_7_497 VGND VGND VPWR VPWR sky130_fd_sc_hd__decap_6
X_3350_ clknet_leaf_37_clk _0183_ net129 VGND VGND VPWR VPWR u_parser.u_decoder.ascii_buf\[11\]\[2\]
+ sky130_fd_sc_hd__dfrtp_1
X_2301_ _0682_ _1102_ _1105_ _1106_ VGND VGND VPWR VPWR _1107_ sky130_fd_sc_hd__a22o_1
X_3281_ clknet_leaf_12_clk _0117_ VGND VGND VPWR VPWR u_rx_fifo.mem\[8\]\[0\] sky130_fd_sc_hd__dfxtp_1
XFILLER_24_3 VGND VGND VPWR VPWR sky130_fd_sc_hd__fill_1
X_2232_ tag_raw\[39\] net504 net53 VGND VGND VPWR VPWR _0236_ sky130_fd_sc_hd__mux2_1
Xclkbuf_leaf_2_clk clknet_3_1__leaf_clk VGND VGND VPWR VPWR clknet_leaf_2_clk sky130_fd_sc_hd__clkbuf_8
XTAP_TAPCELL_ROW_88_1033 VGND VPWR sky130_fd_sc_hd__tapvpwrvgnd_1
X_2163_ net559 net55 _1038_ _1039_ VGND VGND VPWR VPWR _0190_ sky130_fd_sc_hd__a22o_1
XFILLER_38_346 VPWR VGND VPWR VGND sky130_ef_sc_hd__decap_12
X_2094_ tag_raw\[35\] tag_raw\[29\] VGND VGND VPWR VPWR _0972_ sky130_fd_sc_hd__xor2_1
XTAP_TAPCELL_ROW_64_812 VGND VPWR sky130_fd_sc_hd__tapvpwrvgnd_1
XFILLER_65_198 VGND VGND VPWR VPWR sky130_fd_sc_hd__decap_8
XFILLER_0_83 VGND VGND VPWR VPWR sky130_fd_sc_hd__fill_1
XTAP_TAPCELL_ROW_36_547 VGND VPWR sky130_fd_sc_hd__tapvpwrvgnd_1
XFILLER_61_393 VGND VGND VPWR VPWR sky130_fd_sc_hd__decap_8
X_2996_ _1502_ _1503_ VGND VGND VPWR VPWR _0559_ sky130_fd_sc_hd__and2_1
X_1947_ net85 net307 _0944_ VGND VGND VPWR VPWR _0069_ sky130_fd_sc_hd__mux2_1
X_1878_ u_parser.u_packet_encoder.crc_latched\[0\] _0903_ _0907_ _0901_ VGND VGND
+ VPWR VPWR _0908_ sky130_fd_sc_hd__a211o_1
X_3617_ clknet_leaf_22_clk _0444_ net115 VGND VGND VPWR VPWR u_parser.u_decoder.ascii_buf\[0\]\[4\]
+ sky130_fd_sc_hd__dfrtp_1
X_3548_ clknet_leaf_56_clk _0375_ net95 VGND VGND VPWR VPWR u_parser.u_decoder.decoded_payload\[31\]
+ sky130_fd_sc_hd__dfrtp_1
XFILLER_0_139 VGND VGND VPWR VPWR sky130_fd_sc_hd__fill_1
X_3479_ clknet_leaf_41_clk _0306_ net107 VGND VGND VPWR VPWR tag_raw\[33\] sky130_fd_sc_hd__dfrtp_2
XFILLER_29_335 VGND VGND VPWR VPWR sky130_fd_sc_hd__fill_1
XFILLER_56_121 VGND VGND VPWR VPWR sky130_fd_sc_hd__fill_2
XFILLER_69_493 VGND VGND VPWR VPWR sky130_fd_sc_hd__decap_8
XFILLER_71_113 VGND VGND VPWR VPWR sky130_fd_sc_hd__decap_6
XFILLER_52_371 VGND VGND VPWR VPWR sky130_fd_sc_hd__fill_1
XFILLER_4_401 VPWR VGND VPWR VGND sky130_ef_sc_hd__decap_12
XFILLER_4_445 VPWR VGND VPWR VGND sky130_ef_sc_hd__decap_12
XFILLER_4_489 VPWR VGND VPWR VGND sky130_ef_sc_hd__decap_12
XTAP_TAPCELL_ROW_7_272 VGND VPWR sky130_fd_sc_hd__tapvpwrvgnd_1
XFILLER_75_441 VGND VGND VPWR VPWR sky130_fd_sc_hd__decap_6
XFILLER_90_477 VPWR VGND VPWR VGND sky130_ef_sc_hd__decap_12
XTAP_TAPCELL_ROW_33_517 VGND VPWR sky130_fd_sc_hd__tapvpwrvgnd_1
XFILLER_43_371 VGND VGND VPWR VPWR sky130_fd_sc_hd__fill_1
X_2850_ _0891_ _1429_ VGND VGND VPWR VPWR _0487_ sky130_fd_sc_hd__and2_1
X_1801_ _0853_ _0854_ u_rx_fifo.level\[0\] VGND VGND VPWR VPWR _0856_ sky130_fd_sc_hd__a21o_1
X_2781_ _0813_ _1407_ VGND VGND VPWR VPWR _1408_ sky130_fd_sc_hd__nor2_2
XTAP_TAPCELL_ROW_41_594 VGND VPWR sky130_fd_sc_hd__tapvpwrvgnd_1
X_1732_ u_parser.u_decoder.decoded_checksum_rx\[6\] u_parser.u_decoder.decoded_checksum_calc\[6\]
+ VGND VGND VPWR VPWR _0798_ sky130_fd_sc_hd__xnor2_1
Xhold206 u_tx_fifo.mem\[9\]\[2\] VGND VGND VPWR VPWR net362 sky130_fd_sc_hd__dlygate4sd3_1
X_1663_ net58 _0729_ u_rx_fifo.rd_ptr\[3\] VGND VGND VPWR VPWR _0730_ sky130_fd_sc_hd__o21ai_1
Xhold217 u_rx_fifo.mem\[3\]\[2\] VGND VGND VPWR VPWR net373 sky130_fd_sc_hd__dlygate4sd3_1
Xhold228 u_rx_fifo.mem\[5\]\[6\] VGND VGND VPWR VPWR net384 sky130_fd_sc_hd__dlygate4sd3_1
X_3402_ clknet_leaf_56_clk _0235_ net98 VGND VGND VPWR VPWR u_parser.u_packet_encoder.tag_latched\[38\]
+ sky130_fd_sc_hd__dfrtp_1
Xhold239 u_tx_fifo.mem\[3\]\[7\] VGND VGND VPWR VPWR net395 sky130_fd_sc_hd__dlygate4sd3_1
X_1594_ u_uart_rx.break_detect VGND VGND VPWR VPWR _0664_ sky130_fd_sc_hd__inv_2
X_3333_ clknet_leaf_4_clk _0166_ VGND VGND VPWR VPWR u_tx_fifo.mem\[4\]\[1\] sky130_fd_sc_hd__dfxtp_1
X_3264_ clknet_leaf_17_clk _0100_ VGND VGND VPWR VPWR u_rx_fifo.mem\[3\]\[7\] sky130_fd_sc_hd__dfxtp_1
XFILLER_85_216 VGND VGND VPWR VPWR sky130_fd_sc_hd__decap_8
XPHY_EDGE_ROW_7_Right_7 VGND VGND VPWR VPWR sky130_fd_sc_hd__decap_3
XFILLER_58_419 VGND VGND VPWR VPWR sky130_fd_sc_hd__fill_1
X_2215_ tag_raw\[22\] net552 net53 VGND VGND VPWR VPWR _0219_ sky130_fd_sc_hd__mux2_1
X_3195_ clknet_leaf_13_clk _0031_ VGND VGND VPWR VPWR u_rx_fifo.mem\[0\]\[2\] sky130_fd_sc_hd__dfxtp_1
XFILLER_66_441 VGND VGND VPWR VPWR sky130_fd_sc_hd__decap_6
X_2146_ _1019_ _1023_ VGND VGND VPWR VPWR _1024_ sky130_fd_sc_hd__xnor2_1
XFILLER_53_113 VPWR VGND VPWR VGND sky130_ef_sc_hd__decap_12
XFILLER_93_293 VPWR VGND VPWR VGND sky130_ef_sc_hd__decap_12
X_2077_ u_parser.u_decoder.index\[0\] u_parser.u_decoder.index\[1\] VGND VGND VPWR
+ VPWR _0963_ sky130_fd_sc_hd__and2_1
XFILLER_22_533 VPWR VGND VPWR VGND sky130_ef_sc_hd__decap_12
X_2979_ u_uart_rx.low_count\[15\] _1496_ _0668_ VGND VGND VPWR VPWR _1497_ sky130_fd_sc_hd__o21ai_1
XTAP_TAPCELL_ROW_4_242 VGND VPWR sky130_fd_sc_hd__tapvpwrvgnd_1
XFILLER_29_110 VGND VGND VPWR VPWR sky130_fd_sc_hd__fill_2
XFILLER_29_121 VGND VGND VPWR VPWR sky130_fd_sc_hd__decap_4
XFILLER_39_67 VGND VGND VPWR VPWR sky130_fd_sc_hd__decap_4
XTAP_TAPCELL_ROW_75_918 VGND VPWR sky130_fd_sc_hd__tapvpwrvgnd_1
XFILLER_84_293 VPWR VGND VPWR VGND sky130_ef_sc_hd__decap_12
XFILLER_55_55 VGND VGND VPWR VPWR sky130_fd_sc_hd__fill_1
XFILLER_72_477 VGND VGND VPWR VPWR sky130_fd_sc_hd__fill_1
XFILLER_40_341 VPWR VGND VPWR VGND sky130_ef_sc_hd__decap_12
XFILLER_71_54 VGND VGND VPWR VPWR sky130_fd_sc_hd__fill_2
XFILLER_71_87 VGND VGND VPWR VPWR sky130_fd_sc_hd__decap_3
XFILLER_71_98 VGND VGND VPWR VPWR sky130_fd_sc_hd__decap_6
XTAP_TAPCELL_ROW_10_299 VGND VPWR sky130_fd_sc_hd__tapvpwrvgnd_1
X_2000_ net237 net21 _0952_ VGND VGND VPWR VPWR _0114_ sky130_fd_sc_hd__mux2_1
XFILLER_48_441 VPWR VGND VPWR VGND sky130_ef_sc_hd__decap_12
XFILLER_35_113 VGND VGND VPWR VPWR sky130_fd_sc_hd__fill_1
XFILLER_35_146 VGND VGND VPWR VPWR sky130_fd_sc_hd__fill_1
XTAP_TAPCELL_ROW_46_642 VGND VPWR sky130_fd_sc_hd__tapvpwrvgnd_1
X_2902_ u_uart_tx.clk_count\[4\] _1446_ VGND VGND VPWR VPWR _1448_ sky130_fd_sc_hd__and2_1
XTAP_TAPCELL_ROW_18_377 VGND VPWR sky130_fd_sc_hd__tapvpwrvgnd_1
XFILLER_91_3 VPWR VGND VPWR VGND sky130_ef_sc_hd__decap_12
X_2833_ u_tx_fifo.level\[0\] _1416_ _1417_ VGND VGND VPWR VPWR _1419_ sky130_fd_sc_hd__and3_1
X_2764_ u_parser.u_decoder.ascii_buf\[10\]\[1\] u_parser.u_decoder.ascii_buf\[10\]\[2\]
+ u_parser.u_decoder.ascii_buf\[10\]\[3\] VGND VGND VPWR VPWR _1395_ sky130_fd_sc_hd__o21a_1
X_1715_ _0735_ _0769_ _0771_ _0781_ VGND VGND VPWR VPWR _0782_ sky130_fd_sc_hd__o31a_1
X_2695_ net596 _1370_ net12 VGND VGND VPWR VPWR _0391_ sky130_fd_sc_hd__mux2_1
X_1646_ u_rx_fifo.mem\[12\]\[3\] u_rx_fifo.mem\[13\]\[3\] u_rx_fifo.mem\[14\]\[3\]
+ u_rx_fifo.mem\[15\]\[3\] net152 net148 VGND VGND VPWR VPWR _0713_ sky130_fd_sc_hd__mux4_1
X_3316_ clknet_leaf_13_clk _0152_ VGND VGND VPWR VPWR u_rx_fifo.mem\[4\]\[3\] sky130_fd_sc_hd__dfxtp_1
X_3247_ clknet_leaf_21_clk _0083_ VGND VGND VPWR VPWR u_rx_fifo.mem\[14\]\[6\] sky130_fd_sc_hd__dfxtp_1
XTAP_TAPCELL_ROW_1_212 VGND VPWR sky130_fd_sc_hd__tapvpwrvgnd_1
X_3178_ clknet_leaf_19_clk _0014_ net122 VGND VGND VPWR VPWR u_rx_fifo.level\[3\]
+ sky130_fd_sc_hd__dfrtp_1
X_2129_ _1001_ _1006_ VGND VGND VPWR VPWR _1007_ sky130_fd_sc_hd__xor2_2
XFILLER_26_179 VGND VGND VPWR VPWR sky130_fd_sc_hd__fill_1
XTAP_TAPCELL_ROW_80_965 VGND VPWR sky130_fd_sc_hd__tapvpwrvgnd_1
XFILLER_10_525 VGND VGND VPWR VPWR sky130_fd_sc_hd__decap_6
XFILLER_22_363 VGND VGND VPWR VPWR sky130_fd_sc_hd__fill_1
XFILLER_41_57 VPWR VGND VPWR VGND sky130_ef_sc_hd__decap_12
XFILLER_1_245 VGND VGND VPWR VPWR sky130_fd_sc_hd__decap_6
XFILLER_2_29 VGND VGND VPWR VPWR sky130_fd_sc_hd__decap_6
XFILLER_17_113 VGND VGND VPWR VPWR sky130_fd_sc_hd__decap_8
XFILLER_82_53 VPWR VGND VPWR VGND sky130_ef_sc_hd__decap_12
XTAP_TAPCELL_ROW_43_612 VGND VPWR sky130_fd_sc_hd__tapvpwrvgnd_1
XFILLER_60_447 VGND VGND VPWR VPWR sky130_fd_sc_hd__fill_1
XTAP_TAPCELL_ROW_15_347 VGND VPWR sky130_fd_sc_hd__tapvpwrvgnd_1
X_2480_ u_parser.u_decoder.ascii_buf\[9\]\[1\] _1196_ VGND VGND VPWR VPWR _1202_ sky130_fd_sc_hd__xnor2_1
XTAP_TAPCELL_ROW_91_1062 VGND VPWR sky130_fd_sc_hd__tapvpwrvgnd_1
X_3101_ u_uart_rx.state\[2\] _0698_ _1553_ VGND VGND VPWR VPWR _1554_ sky130_fd_sc_hd__a21o_1
XFILLER_68_525 VGND VGND VPWR VPWR sky130_fd_sc_hd__decap_6
X_3032_ net202 net73 _1507_ VGND VGND VPWR VPWR _0591_ sky130_fd_sc_hd__mux2_1
XFILLER_36_444 VGND VGND VPWR VPWR sky130_fd_sc_hd__decap_8
XFILLER_36_477 VPWR VGND VPWR VGND sky130_ef_sc_hd__decap_12
XFILLER_23_105 VGND VGND VPWR VPWR sky130_fd_sc_hd__decap_6
XFILLER_51_414 VGND VGND VPWR VPWR sky130_fd_sc_hd__fill_1
X_2816_ _0964_ _1407_ net514 VGND VGND VPWR VPWR _0471_ sky130_fd_sc_hd__o21a_1
X_3796_ clknet_leaf_27_clk _0614_ net123 VGND VGND VPWR VPWR u_uart_rx.bit_index\[0\]
+ sky130_fd_sc_hd__dfrtp_2
X_2747_ u_parser.u_decoder.ascii_buf\[11\]\[7\] u_parser.u_decoder.ascii_buf\[11\]\[6\]
+ _1380_ _1381_ VGND VGND VPWR VPWR _1382_ sky130_fd_sc_hd__nor4_1
X_2678_ _1355_ _1356_ VGND VGND VPWR VPWR _1357_ sky130_fd_sc_hd__xnor2_1
X_1629_ u_uart_rx.bit_index\[1\] u_uart_rx.bit_index\[0\] VGND VGND VPWR VPWR _0699_
+ sky130_fd_sc_hd__nand2_1
XFILLER_59_525 VPWR VGND VPWR VGND sky130_ef_sc_hd__decap_12
XFILLER_39_293 VGND VGND VPWR VPWR sky130_fd_sc_hd__decap_4
XTAP_TAPCELL_ROW_12_317 VGND VPWR sky130_fd_sc_hd__tapvpwrvgnd_1
XFILLER_50_491 VGND VGND VPWR VPWR sky130_fd_sc_hd__decap_6
XTAP_TAPCELL_ROW_20_394 VGND VPWR sky130_fd_sc_hd__tapvpwrvgnd_1
XFILLER_93_41 VPWR VGND VPWR VGND sky130_ef_sc_hd__decap_12
XFILLER_18_433 VGND VGND VPWR VPWR sky130_fd_sc_hd__fill_1
XFILLER_93_85 VGND VGND VPWR VPWR sky130_fd_sc_hd__decap_4
XTAP_TAPCELL_ROW_28_472 VGND VPWR sky130_fd_sc_hd__tapvpwrvgnd_1
X_1980_ net74 net374 _0948_ VGND VGND VPWR VPWR _0098_ sky130_fd_sc_hd__mux2_1
XFILLER_33_469 VGND VGND VPWR VPWR sky130_fd_sc_hd__decap_4
X_3650_ clknet_leaf_7_clk _0477_ net95 VGND VGND VPWR VPWR u_parser.u_decoder.ascii_buf\[4\]\[5\]
+ sky130_fd_sc_hd__dfrtp_1
X_3581_ clknet_leaf_34_clk _0408_ net134 VGND VGND VPWR VPWR u_parser.u_decoder.ascii_buf\[7\]\[0\]
+ sky130_fd_sc_hd__dfrtp_1
X_2601_ u_parser.u_decoder.ascii_buf\[2\]\[4\] u_parser.u_decoder.ascii_buf\[2\]\[5\]
+ _1294_ _1295_ VGND VGND VPWR VPWR _1296_ sky130_fd_sc_hd__and4_1
X_2532_ u_parser.u_decoder.ascii_buf\[6\]\[0\] u_parser.u_decoder.ascii_buf\[6\]\[1\]
+ u_parser.u_decoder.ascii_buf\[6\]\[2\] u_parser.u_decoder.ascii_buf\[6\]\[3\] _1242_
+ VGND VGND VPWR VPWR _1243_ sky130_fd_sc_hd__o41a_1
XFILLER_54_3 VPWR VGND VPWR VGND sky130_ef_sc_hd__decap_12
X_2463_ net3 _1187_ _1188_ VGND VGND VPWR VPWR _0341_ sky130_fd_sc_hd__and3_1
X_2394_ u_parser.u_decoder.ascii_buf\[5\]\[3\] net44 _1144_ VGND VGND VPWR VPWR _0316_
+ sky130_fd_sc_hd__mux2_1
XFILLER_68_300 VGND VGND VPWR VPWR sky130_fd_sc_hd__decap_8
XFILLER_68_333 VPWR VGND VPWR VGND sky130_ef_sc_hd__decap_12
XFILLER_83_358 VGND VGND VPWR VPWR sky130_fd_sc_hd__decap_6
X_3015_ net29 net251 _1505_ VGND VGND VPWR VPWR _0576_ sky130_fd_sc_hd__mux2_1
XTAP_TAPCELL_ROW_54_718 VGND VPWR sky130_fd_sc_hd__tapvpwrvgnd_1
XFILLER_11_108 VGND VGND VPWR VPWR sky130_fd_sc_hd__decap_4
XTAP_TAPCELL_ROW_62_795 VGND VPWR sky130_fd_sc_hd__tapvpwrvgnd_1
X_3779_ clknet_leaf_27_clk _0597_ net138 VGND VGND VPWR VPWR u_uart_rx.sample_phase\[4\]
+ sky130_fd_sc_hd__dfrtp_1
Xfanout121 net126 VGND VGND VPWR VPWR net121 sky130_fd_sc_hd__buf_2
Xfanout110 net112 VGND VGND VPWR VPWR net110 sky130_fd_sc_hd__buf_2
XFILLER_86_141 VGND VGND VPWR VPWR sky130_fd_sc_hd__decap_6
Xfanout154 u_rx_fifo.rd_ptr\[0\] VGND VGND VPWR VPWR net154 sky130_fd_sc_hd__clkbuf_4
Xfanout143 net144 VGND VGND VPWR VPWR net143 sky130_fd_sc_hd__clkbuf_2
Xfanout132 net135 VGND VGND VPWR VPWR net132 sky130_fd_sc_hd__buf_2
XFILLER_27_241 VGND VGND VPWR VPWR sky130_fd_sc_hd__fill_1
XFILLER_15_458 VGND VGND VPWR VPWR sky130_fd_sc_hd__decap_4
XTAP_TAPCELL_ROW_25_442 VGND VPWR sky130_fd_sc_hd__tapvpwrvgnd_1
XFILLER_63_55 VGND VGND VPWR VPWR sky130_fd_sc_hd__fill_1
XFILLER_70_553 VGND VGND VPWR VPWR sky130_fd_sc_hd__fill_2
XFILLER_30_428 VGND VGND VPWR VPWR sky130_fd_sc_hd__decap_4
XFILLER_10_141 VPWR VGND VPWR VGND sky130_ef_sc_hd__decap_12
XFILLER_88_41 VPWR VGND VPWR VGND sky130_ef_sc_hd__decap_12
XPHY_EDGE_ROW_0_Left_94 VGND VGND VPWR VPWR sky130_fd_sc_hd__decap_3
XFILLER_53_509 VGND VGND VPWR VPWR sky130_fd_sc_hd__fill_2
XFILLER_80_317 VGND VGND VPWR VPWR sky130_fd_sc_hd__decap_3
X_1963_ net183 net71 _0945_ VGND VGND VPWR VPWR _0084_ sky130_fd_sc_hd__mux2_1
X_3702_ clknet_leaf_49_clk _0526_ net91 VGND VGND VPWR VPWR u_uart_tx.clk_count\[9\]
+ sky130_fd_sc_hd__dfrtp_1
X_1894_ u_parser.u_packet_encoder.tag_latched\[11\] _0894_ VGND VGND VPWR VPWR _0921_
+ sky130_fd_sc_hd__and2_1
X_3633_ clknet_leaf_21_clk _0460_ net118 VGND VGND VPWR VPWR u_parser.u_decoder.ascii_buf\[2\]\[4\]
+ sky130_fd_sc_hd__dfrtp_1
X_3564_ clknet_leaf_38_clk _0391_ net127 VGND VGND VPWR VPWR u_parser.u_decoder.decoded_checksum_calc\[7\]
+ sky130_fd_sc_hd__dfrtp_1
X_3495_ clknet_leaf_23_clk _0322_ net119 VGND VGND VPWR VPWR u_parser.u_decoder.index\[1\]
+ sky130_fd_sc_hd__dfrtp_4
X_2515_ u_parser.u_decoder.ascii_buf\[7\]\[0\] _1229_ _1226_ VGND VGND VPWR VPWR _1230_
+ sky130_fd_sc_hd__o21a_1
X_2446_ net618 _1174_ _1176_ VGND VGND VPWR VPWR _0336_ sky130_fd_sc_hd__a21oi_1
X_2377_ tag_raw\[30\] net475 net16 VGND VGND VPWR VPWR _0303_ sky130_fd_sc_hd__mux2_1
XFILLER_83_166 VGND VGND VPWR VPWR sky130_fd_sc_hd__fill_2
XFILLER_71_306 VGND VGND VPWR VPWR sky130_fd_sc_hd__fill_1
XFILLER_52_553 VGND VGND VPWR VPWR sky130_fd_sc_hd__fill_2
XFILLER_12_439 VGND VGND VPWR VPWR sky130_fd_sc_hd__fill_1
XTAP_TAPCELL_ROW_22_412 VGND VPWR sky130_fd_sc_hd__tapvpwrvgnd_1
XPHY_EDGE_ROW_18_Left_112 VGND VGND VPWR VPWR sky130_fd_sc_hd__decap_3
XFILLER_59_130 VGND VGND VPWR VPWR sky130_fd_sc_hd__decap_8
XPHY_EDGE_ROW_27_Left_121 VGND VGND VPWR VPWR sky130_fd_sc_hd__decap_3
XFILLER_15_211 VPWR VGND VPWR VGND sky130_ef_sc_hd__decap_12
XFILLER_43_520 VGND VGND VPWR VPWR sky130_fd_sc_hd__fill_1
XFILLER_70_361 VGND VGND VPWR VPWR sky130_fd_sc_hd__decap_3
XFILLER_90_53 VPWR VGND VPWR VGND sky130_ef_sc_hd__decap_12
XFILLER_30_214 VGND VGND VPWR VPWR sky130_fd_sc_hd__decap_8
XFILLER_90_97 VGND VGND VPWR VPWR sky130_fd_sc_hd__fill_1
XFILLER_11_461 VPWR VGND VPWR VGND sky130_ef_sc_hd__decap_12
XPHY_EDGE_ROW_36_Left_130 VGND VGND VPWR VPWR sky130_fd_sc_hd__decap_3
X_2300_ net60 _1103_ u_tx_fifo.rd_ptr\[3\] VGND VGND VPWR VPWR _1106_ sky130_fd_sc_hd__o21a_1
X_3280_ clknet_leaf_0_clk _0116_ VGND VGND VPWR VPWR u_tx_fifo.mem\[12\]\[7\] sky130_fd_sc_hd__dfxtp_1
X_2231_ tag_raw\[38\] net517 net53 VGND VGND VPWR VPWR _0235_ sky130_fd_sc_hd__mux2_1
XFILLER_17_3 VGND VGND VPWR VPWR sky130_fd_sc_hd__decap_8
X_2162_ _1029_ _1037_ net55 VGND VGND VPWR VPWR _1039_ sky130_fd_sc_hd__o21ba_1
XTAP_TAPCELL_ROW_88_1034 VGND VPWR sky130_fd_sc_hd__tapvpwrvgnd_1
X_2093_ tag_raw\[37\] tag_raw\[36\] VGND VGND VPWR VPWR _0971_ sky130_fd_sc_hd__xor2_4
XFILLER_38_358 VGND VGND VPWR VPWR sky130_fd_sc_hd__decap_6
XTAP_TAPCELL_ROW_64_813 VGND VPWR sky130_fd_sc_hd__tapvpwrvgnd_1
XFILLER_65_188 VGND VGND VPWR VPWR sky130_fd_sc_hd__fill_2
XFILLER_34_531 VGND VGND VPWR VPWR sky130_fd_sc_hd__fill_1
XFILLER_34_553 VGND VGND VPWR VPWR sky130_fd_sc_hd__fill_2
XTAP_TAPCELL_ROW_36_548 VGND VPWR sky130_fd_sc_hd__tapvpwrvgnd_1
XFILLER_61_361 VGND VGND VPWR VPWR sky130_fd_sc_hd__decap_8
XFILLER_21_225 VGND VGND VPWR VPWR sky130_fd_sc_hd__fill_1
XTAP_TAPCELL_ROW_72_890 VGND VPWR sky130_fd_sc_hd__tapvpwrvgnd_1
X_2995_ u_uart_tx.bit_index\[0\] _1499_ u_uart_tx.bit_index\[1\] VGND VGND VPWR VPWR
+ _1503_ sky130_fd_sc_hd__a21o_1
X_1946_ _0868_ _0873_ VGND VGND VPWR VPWR _0944_ sky130_fd_sc_hd__or2_4
X_1877_ u_parser.u_packet_encoder.tag_latched\[0\] _0902_ _0906_ _0878_ VGND VGND
+ VPWR VPWR _0907_ sky130_fd_sc_hd__a22o_1
X_3616_ clknet_leaf_22_clk _0443_ net117 VGND VGND VPWR VPWR u_parser.u_decoder.ascii_buf\[0\]\[3\]
+ sky130_fd_sc_hd__dfrtp_1
X_3547_ clknet_leaf_56_clk _0374_ net97 VGND VGND VPWR VPWR u_parser.u_decoder.decoded_payload\[30\]
+ sky130_fd_sc_hd__dfrtp_1
X_3478_ clknet_leaf_43_clk _0305_ net107 VGND VGND VPWR VPWR tag_raw\[32\] sky130_fd_sc_hd__dfrtp_4
X_2429_ _1151_ _1164_ VGND VGND VPWR VPWR _1165_ sky130_fd_sc_hd__nor2_1
XFILLER_84_475 VGND VGND VPWR VPWR sky130_fd_sc_hd__fill_1
XFILLER_44_306 VGND VGND VPWR VPWR sky130_fd_sc_hd__fill_2
XFILLER_37_391 VGND VGND VPWR VPWR sky130_fd_sc_hd__fill_1
XFILLER_12_225 VGND VGND VPWR VPWR sky130_fd_sc_hd__fill_2
XFILLER_52_383 VGND VGND VPWR VPWR sky130_fd_sc_hd__decap_3
XFILLER_4_413 VGND VGND VPWR VPWR sky130_fd_sc_hd__decap_6
XFILLER_4_457 VPWR VGND VPWR VGND sky130_ef_sc_hd__decap_12
XFILLER_79_225 VGND VGND VPWR VPWR sky130_fd_sc_hd__fill_1
XTAP_TAPCELL_ROW_78_938 VGND VPWR sky130_fd_sc_hd__tapvpwrvgnd_1
XFILLER_47_111 VGND VGND VPWR VPWR sky130_fd_sc_hd__fill_1
XFILLER_75_486 VPWR VGND VPWR VGND sky130_ef_sc_hd__decap_12
XFILLER_47_166 VGND VGND VPWR VPWR sky130_fd_sc_hd__fill_2
XFILLER_90_489 VPWR VGND VPWR VGND sky130_ef_sc_hd__decap_12
XFILLER_16_553 VGND VGND VPWR VPWR sky130_fd_sc_hd__fill_2
XTAP_TAPCELL_ROW_33_518 VGND VPWR sky130_fd_sc_hd__tapvpwrvgnd_1
XFILLER_50_309 VPWR VGND VPWR VGND sky130_ef_sc_hd__decap_12
X_1800_ u_rx_fifo.level\[0\] _0853_ _0854_ VGND VGND VPWR VPWR _0855_ sky130_fd_sc_hd__nand3_1
X_2780_ u_parser.u_decoder.index\[2\] u_parser.u_decoder.index\[3\] _0965_ VGND VGND
+ VPWR VPWR _1407_ sky130_fd_sc_hd__or3_4
XTAP_TAPCELL_ROW_41_595 VGND VPWR sky130_fd_sc_hd__tapvpwrvgnd_1
X_1731_ _0796_ _0797_ _0784_ _0794_ VGND VGND VPWR VPWR _0003_ sky130_fd_sc_hd__a211o_1
Xhold207 u_tx_fifo.mem\[5\]\[4\] VGND VGND VPWR VPWR net363 sky130_fd_sc_hd__dlygate4sd3_1
X_1662_ u_rx_fifo.mem\[12\]\[7\] u_rx_fifo.mem\[13\]\[7\] u_rx_fifo.mem\[14\]\[7\]
+ u_rx_fifo.mem\[15\]\[7\] net152 net148 VGND VGND VPWR VPWR _0729_ sky130_fd_sc_hd__mux4_1
Xhold218 u_rx_fifo.mem\[3\]\[5\] VGND VGND VPWR VPWR net374 sky130_fd_sc_hd__dlygate4sd3_1
X_3401_ clknet_leaf_55_clk _0234_ net100 VGND VGND VPWR VPWR u_parser.u_packet_encoder.tag_latched\[37\]
+ sky130_fd_sc_hd__dfrtp_1
Xhold229 u_tx_fifo.mem\[7\]\[2\] VGND VGND VPWR VPWR net385 sky130_fd_sc_hd__dlygate4sd3_1
X_1593_ u_uart_rx.bit_index\[0\] VGND VGND VPWR VPWR _0663_ sky130_fd_sc_hd__inv_2
X_3332_ clknet_leaf_5_clk _0165_ VGND VGND VPWR VPWR u_tx_fifo.mem\[4\]\[0\] sky130_fd_sc_hd__dfxtp_1
X_3263_ clknet_leaf_17_clk _0099_ VGND VGND VPWR VPWR u_rx_fifo.mem\[3\]\[6\] sky130_fd_sc_hd__dfxtp_1
X_3194_ clknet_leaf_17_clk _0030_ VGND VGND VPWR VPWR u_rx_fifo.mem\[0\]\[1\] sky130_fd_sc_hd__dfxtp_1
XFILLER_78_280 VGND VGND VPWR VPWR sky130_fd_sc_hd__fill_1
X_2214_ tag_raw\[21\] net539 net53 VGND VGND VPWR VPWR _0218_ sky130_fd_sc_hd__mux2_1
X_2145_ _0994_ _1022_ VGND VGND VPWR VPWR _1023_ sky130_fd_sc_hd__xor2_2
XFILLER_66_475 VGND VGND VPWR VPWR sky130_fd_sc_hd__fill_1
XFILLER_81_445 VGND VGND VPWR VPWR sky130_fd_sc_hd__decap_3
X_2076_ net29 net395 _0962_ VGND VGND VPWR VPWR _0180_ sky130_fd_sc_hd__mux2_1
XFILLER_53_125 VGND VGND VPWR VPWR sky130_fd_sc_hd__fill_1
XFILLER_81_478 VGND VGND VPWR VPWR sky130_fd_sc_hd__fill_1
Xclkbuf_3_5__f_clk clknet_0_clk VGND VGND VPWR VPWR clknet_3_5__leaf_clk sky130_fd_sc_hd__clkbuf_16
XFILLER_22_545 VGND VGND VPWR VPWR sky130_fd_sc_hd__decap_8
X_2978_ net87 _1495_ _1496_ VGND VGND VPWR VPWR _0548_ sky130_fd_sc_hd__nor3_1
X_1929_ net83 net314 _0874_ VGND VGND VPWR VPWR _0054_ sky130_fd_sc_hd__mux2_1
XFILLER_30_15 VPWR VGND VPWR VGND sky130_ef_sc_hd__decap_12
XFILLER_89_501 VGND VGND VPWR VPWR sky130_fd_sc_hd__decap_3
XFILLER_1_405 VPWR VGND VPWR VGND sky130_ef_sc_hd__decap_12
XFILLER_1_449 VPWR VGND VPWR VGND sky130_ef_sc_hd__decap_12
XFILLER_39_57 VGND VGND VPWR VPWR sky130_fd_sc_hd__fill_1
XFILLER_39_79 VGND VGND VPWR VPWR sky130_fd_sc_hd__decap_4
XTAP_TAPCELL_ROW_4_243 VGND VPWR sky130_fd_sc_hd__tapvpwrvgnd_1
XFILLER_84_283 VGND VGND VPWR VPWR sky130_fd_sc_hd__fill_1
XFILLER_13_501 VGND VGND VPWR VPWR sky130_fd_sc_hd__decap_3
XFILLER_32_309 VGND VGND VPWR VPWR sky130_fd_sc_hd__fill_2
XFILLER_9_505 VPWR VGND VPWR VGND sky130_ef_sc_hd__decap_12
XFILLER_40_353 VGND VGND VPWR VPWR sky130_fd_sc_hd__decap_8
XFILLER_40_386 VGND VGND VPWR VPWR sky130_fd_sc_hd__decap_6
XFILLER_71_66 VGND VGND VPWR VPWR sky130_fd_sc_hd__decap_4
XFILLER_20_81 VGND VGND VPWR VPWR sky130_fd_sc_hd__decap_3
XFILLER_48_453 VPWR VGND VPWR VGND sky130_ef_sc_hd__decap_12
Xhold90 u_tx_fifo.mem\[14\]\[1\] VGND VGND VPWR VPWR net246 sky130_fd_sc_hd__dlygate4sd3_1
XTAP_TAPCELL_ROW_46_643 VGND VPWR sky130_fd_sc_hd__tapvpwrvgnd_1
XFILLER_48_497 VPWR VGND VPWR VGND sky130_ef_sc_hd__decap_12
X_2901_ _1446_ _1447_ VGND VGND VPWR VPWR _0520_ sky130_fd_sc_hd__nor2_1
XFILLER_50_139 VGND VGND VPWR VPWR sky130_fd_sc_hd__fill_1
XFILLER_43_180 VGND VGND VPWR VPWR sky130_fd_sc_hd__fill_1
XFILLER_84_3 VPWR VGND VPWR VGND sky130_ef_sc_hd__decap_12
X_2832_ _1416_ _1417_ u_tx_fifo.level\[0\] VGND VGND VPWR VPWR _1418_ sky130_fd_sc_hd__a21oi_1
X_2763_ u_parser.u_decoder.ascii_buf\[10\]\[0\] u_parser.u_decoder.ascii_buf\[10\]\[1\]
+ u_parser.u_decoder.ascii_buf\[10\]\[2\] u_parser.u_decoder.ascii_buf\[10\]\[3\]
+ _1393_ VGND VGND VPWR VPWR _1394_ sky130_fd_sc_hd__o41a_1
X_1714_ net44 _0770_ _0780_ VGND VGND VPWR VPWR _0781_ sky130_fd_sc_hd__a21bo_1
X_2694_ _1367_ _1369_ VGND VGND VPWR VPWR _1370_ sky130_fd_sc_hd__xnor2_1
X_1645_ net145 _0711_ VGND VGND VPWR VPWR _0712_ sky130_fd_sc_hd__or2_1
XFILLER_58_206 VGND VGND VPWR VPWR sky130_fd_sc_hd__decap_3
X_3315_ clknet_leaf_13_clk _0151_ VGND VGND VPWR VPWR u_rx_fifo.mem\[4\]\[2\] sky130_fd_sc_hd__dfxtp_1
X_3246_ clknet_leaf_9_clk _0082_ VGND VGND VPWR VPWR u_rx_fifo.mem\[14\]\[5\] sky130_fd_sc_hd__dfxtp_1
XTAP_TAPCELL_ROW_1_213 VGND VPWR sky130_fd_sc_hd__tapvpwrvgnd_1
XFILLER_39_464 VPWR VGND VPWR VGND sky130_ef_sc_hd__decap_12
X_3177_ clknet_leaf_19_clk _0013_ net122 VGND VGND VPWR VPWR u_rx_fifo.level\[2\]
+ sky130_fd_sc_hd__dfrtp_1
XFILLER_81_220 VGND VGND VPWR VPWR sky130_fd_sc_hd__decap_4
X_2128_ _1004_ _1005_ VGND VGND VPWR VPWR _1006_ sky130_fd_sc_hd__xnor2_2
XFILLER_66_283 VGND VGND VPWR VPWR sky130_fd_sc_hd__fill_1
X_2059_ net225 net28 _0960_ VGND VGND VPWR VPWR _0165_ sky130_fd_sc_hd__mux2_1
XFILLER_81_275 VGND VGND VPWR VPWR sky130_fd_sc_hd__decap_4
XTAP_TAPCELL_ROW_80_966 VGND VPWR sky130_fd_sc_hd__tapvpwrvgnd_1
XFILLER_22_320 VGND VGND VPWR VPWR sky130_fd_sc_hd__decap_3
XFILLER_41_69 VGND VGND VPWR VPWR sky130_fd_sc_hd__decap_3
XFILLER_1_202 VPWR VGND VPWR VGND sky130_ef_sc_hd__decap_12
XFILLER_77_548 VGND VGND VPWR VPWR sky130_fd_sc_hd__decap_6
XFILLER_1_279 VGND VGND VPWR VPWR sky130_fd_sc_hd__fill_1
XFILLER_49_206 VGND VGND VPWR VPWR sky130_fd_sc_hd__decap_4
XFILLER_82_65 VGND VGND VPWR VPWR sky130_fd_sc_hd__fill_2
XFILLER_32_106 VGND VGND VPWR VPWR sky130_fd_sc_hd__decap_3
XTAP_TAPCELL_ROW_43_613 VGND VPWR sky130_fd_sc_hd__tapvpwrvgnd_1
XFILLER_72_286 VGND VGND VPWR VPWR sky130_fd_sc_hd__decap_3
XTAP_TAPCELL_ROW_15_348 VGND VPWR sky130_fd_sc_hd__tapvpwrvgnd_1
XFILLER_32_139 VGND VGND VPWR VPWR sky130_fd_sc_hd__fill_1
XFILLER_9_313 VGND VGND VPWR VPWR sky130_fd_sc_hd__decap_4
XTAP_TAPCELL_ROW_51_690 VGND VPWR sky130_fd_sc_hd__tapvpwrvgnd_1
XFILLER_5_541 VPWR VGND VPWR VGND sky130_ef_sc_hd__decap_12
XTAP_TAPCELL_ROW_91_1063 VGND VPWR sky130_fd_sc_hd__tapvpwrvgnd_1
X_3100_ u_uart_rx.state\[2\] _0820_ VGND VGND VPWR VPWR _1553_ sky130_fd_sc_hd__nor2_1
X_3031_ net248 net75 _1507_ VGND VGND VPWR VPWR _0590_ sky130_fd_sc_hd__mux2_1
XFILLER_36_489 VPWR VGND VPWR VGND sky130_ef_sc_hd__decap_12
XFILLER_23_139 VPWR VGND VPWR VGND sky130_ef_sc_hd__decap_12
X_2815_ net563 net42 _1411_ VGND VGND VPWR VPWR _0470_ sky130_fd_sc_hd__mux2_1
X_3795_ clknet_leaf_31_clk _0613_ net142 VGND VGND VPWR VPWR u_uart_rx.sample_div_count\[15\]
+ sky130_fd_sc_hd__dfrtp_1
XFILLER_11_39 VGND VGND VPWR VPWR sky130_fd_sc_hd__fill_1
X_2746_ u_parser.u_decoder.ascii_buf\[11\]\[4\] u_parser.u_decoder.ascii_buf\[11\]\[5\]
+ VGND VGND VPWR VPWR _1381_ sky130_fd_sc_hd__nand2_1
X_2677_ _1215_ _1244_ VGND VGND VPWR VPWR _1356_ sky130_fd_sc_hd__xnor2_1
X_1628_ u_uart_rx.break_detect _0697_ VGND VGND VPWR VPWR _0698_ sky130_fd_sc_hd__nor2_1
XFILLER_59_537 VPWR VGND VPWR VGND sky130_ef_sc_hd__decap_12
X_3229_ clknet_leaf_11_clk _0065_ VGND VGND VPWR VPWR u_rx_fifo.mem\[10\]\[4\] sky130_fd_sc_hd__dfxtp_1
XFILLER_27_478 VGND VGND VPWR VPWR sky130_fd_sc_hd__fill_1
XFILLER_42_404 VGND VGND VPWR VPWR sky130_fd_sc_hd__fill_2
XFILLER_42_437 VGND VGND VPWR VPWR sky130_fd_sc_hd__fill_1
XFILLER_54_286 VGND VGND VPWR VPWR sky130_fd_sc_hd__fill_2
XTAP_TAPCELL_ROW_12_318 VGND VPWR sky130_fd_sc_hd__tapvpwrvgnd_1
XFILLER_10_345 VPWR VGND VPWR VGND sky130_ef_sc_hd__decap_12
XTAP_TAPCELL_ROW_20_395 VGND VPWR sky130_fd_sc_hd__tapvpwrvgnd_1
XFILLER_2_533 VPWR VGND VPWR VGND sky130_ef_sc_hd__decap_12
Xhold390 u_parser.u_packet_encoder.tag_latched\[30\] VGND VGND VPWR VPWR net546 sky130_fd_sc_hd__dlygate4sd3_1
XFILLER_77_301 VGND VGND VPWR VPWR sky130_fd_sc_hd__decap_8
XFILLER_93_53 VGND VGND VPWR VPWR sky130_fd_sc_hd__decap_3
XFILLER_9_165 VGND VGND VPWR VPWR sky130_fd_sc_hd__decap_3
X_2600_ u_parser.u_decoder.ascii_buf\[2\]\[7\] u_parser.u_decoder.ascii_buf\[2\]\[6\]
+ VGND VGND VPWR VPWR _1295_ sky130_fd_sc_hd__nor2_1
X_3580_ clknet_leaf_37_clk _0407_ net129 VGND VGND VPWR VPWR u_parser.u_decoder.ascii_buf\[10\]\[7\]
+ sky130_fd_sc_hd__dfrtp_1
X_2531_ u_parser.u_decoder.ascii_buf\[6\]\[0\] u_parser.u_decoder.ascii_buf\[6\]\[1\]
+ u_parser.u_decoder.ascii_buf\[6\]\[2\] _1241_ VGND VGND VPWR VPWR _1242_ sky130_fd_sc_hd__a31oi_1
XFILLER_5_393 VPWR VGND VPWR VGND sky130_ef_sc_hd__decap_12
XFILLER_47_3 VPWR VGND VPWR VGND sky130_ef_sc_hd__decap_12
X_2462_ u_parser.u_decoder.timeout_count\[15\] u_parser.u_decoder.timeout_count\[16\]
+ _1184_ VGND VGND VPWR VPWR _1188_ sky130_fd_sc_hd__nand3_1
X_2393_ u_parser.u_decoder.ascii_buf\[5\]\[2\] net36 _1144_ VGND VGND VPWR VPWR _0315_
+ sky130_fd_sc_hd__mux2_1
XFILLER_68_345 VPWR VGND VPWR VGND sky130_ef_sc_hd__decap_12
XFILLER_28_209 VGND VGND VPWR VPWR sky130_fd_sc_hd__decap_4
XFILLER_68_389 VGND VGND VPWR VPWR sky130_fd_sc_hd__fill_1
XFILLER_83_326 VGND VGND VPWR VPWR sky130_fd_sc_hd__fill_1
X_3014_ net19 net379 _1505_ VGND VGND VPWR VPWR _0575_ sky130_fd_sc_hd__mux2_1
XTAP_TAPCELL_ROW_54_719 VGND VPWR sky130_fd_sc_hd__tapvpwrvgnd_1
XFILLER_24_404 VPWR VGND VPWR VGND sky130_ef_sc_hd__decap_12
XFILLER_36_286 VGND VGND VPWR VPWR sky130_fd_sc_hd__fill_2
XFILLER_24_459 VPWR VGND VPWR VGND sky130_ef_sc_hd__decap_12
XFILLER_51_223 VGND VGND VPWR VPWR sky130_fd_sc_hd__fill_1
XFILLER_51_234 VGND VGND VPWR VPWR sky130_fd_sc_hd__decap_8
XFILLER_22_27 VGND VGND VPWR VPWR sky130_fd_sc_hd__fill_1
X_3778_ clknet_leaf_27_clk _0596_ net124 VGND VGND VPWR VPWR u_uart_rx.sample_phase\[3\]
+ sky130_fd_sc_hd__dfrtp_1
X_2729_ net43 net608 _1375_ VGND VGND VPWR VPWR _0420_ sky130_fd_sc_hd__mux2_1
Xfanout111 net112 VGND VGND VPWR VPWR net111 sky130_fd_sc_hd__clkbuf_4
Xfanout100 net101 VGND VGND VPWR VPWR net100 sky130_fd_sc_hd__buf_2
Xfanout122 net125 VGND VGND VPWR VPWR net122 sky130_fd_sc_hd__clkbuf_4
Xfanout155 u_parser.u_decoder.state\[1\] VGND VGND VPWR VPWR net155 sky130_fd_sc_hd__buf_2
XFILLER_59_334 VGND VGND VPWR VPWR sky130_fd_sc_hd__fill_2
Xfanout133 net135 VGND VGND VPWR VPWR net133 sky130_fd_sc_hd__clkbuf_4
Xfanout144 net157 VGND VGND VPWR VPWR net144 sky130_fd_sc_hd__clkbuf_2
XFILLER_59_367 VGND VGND VPWR VPWR sky130_fd_sc_hd__fill_2
XFILLER_59_389 VGND VGND VPWR VPWR sky130_fd_sc_hd__decap_3
XPHY_EDGE_ROW_29_Right_29 VGND VGND VPWR VPWR sky130_fd_sc_hd__decap_3
XFILLER_47_57 VPWR VGND VPWR VGND sky130_ef_sc_hd__decap_12
XFILLER_27_231 VGND VGND VPWR VPWR sky130_fd_sc_hd__fill_1
XTAP_TAPCELL_ROW_25_443 VGND VPWR sky130_fd_sc_hd__tapvpwrvgnd_1
XFILLER_8_29 VGND VGND VPWR VPWR sky130_fd_sc_hd__decap_4
XPHY_EDGE_ROW_38_Right_38 VGND VGND VPWR VPWR sky130_fd_sc_hd__decap_3
XFILLER_10_153 VGND VGND VPWR VPWR sky130_fd_sc_hd__fill_1
XFILLER_88_53 VGND VGND VPWR VPWR sky130_fd_sc_hd__decap_6
XFILLER_2_363 VGND VGND VPWR VPWR sky130_fd_sc_hd__fill_1
XFILLER_77_131 VGND VGND VPWR VPWR sky130_fd_sc_hd__fill_2
XFILLER_77_164 VGND VGND VPWR VPWR sky130_fd_sc_hd__decap_4
XPHY_EDGE_ROW_47_Right_47 VGND VGND VPWR VPWR sky130_fd_sc_hd__decap_3
XFILLER_18_286 VPWR VGND VPWR VGND sky130_ef_sc_hd__decap_12
XFILLER_18_253 VPWR VGND VPWR VGND sky130_ef_sc_hd__decap_12
XFILLER_33_212 VGND VGND VPWR VPWR sky130_fd_sc_hd__decap_4
XFILLER_61_554 VGND VGND VPWR VPWR sky130_fd_sc_hd__fill_1
XFILLER_33_289 VGND VGND VPWR VPWR sky130_fd_sc_hd__decap_8
XPHY_EDGE_ROW_56_Right_56 VGND VGND VPWR VPWR sky130_fd_sc_hd__decap_3
X_1962_ net252 net73 _0945_ VGND VGND VPWR VPWR _0083_ sky130_fd_sc_hd__mux2_1
X_1893_ u_parser.u_packet_encoder.tag_latched\[19\] _0899_ _0902_ u_parser.u_packet_encoder.tag_latched\[3\]
+ VGND VGND VPWR VPWR _0920_ sky130_fd_sc_hd__a22o_1
X_3701_ clknet_leaf_49_clk _0525_ net102 VGND VGND VPWR VPWR u_uart_tx.clk_count\[8\]
+ sky130_fd_sc_hd__dfrtp_1
X_3632_ clknet_leaf_21_clk _0459_ net118 VGND VGND VPWR VPWR u_parser.u_decoder.ascii_buf\[2\]\[3\]
+ sky130_fd_sc_hd__dfrtp_1
X_3563_ clknet_leaf_38_clk _0390_ net127 VGND VGND VPWR VPWR u_parser.u_decoder.decoded_checksum_calc\[6\]
+ sky130_fd_sc_hd__dfrtp_1
X_2514_ u_parser.u_decoder.ascii_buf\[7\]\[0\] u_parser.u_decoder.ascii_buf\[7\]\[1\]
+ u_parser.u_decoder.ascii_buf\[7\]\[2\] u_parser.u_decoder.ascii_buf\[7\]\[3\] _1228_
+ VGND VGND VPWR VPWR _1229_ sky130_fd_sc_hd__o41a_1
X_3494_ clknet_leaf_24_clk _0321_ net118 VGND VGND VPWR VPWR u_parser.u_decoder.index\[0\]
+ sky130_fd_sc_hd__dfrtp_4
XPHY_EDGE_ROW_65_Right_65 VGND VGND VPWR VPWR sky130_fd_sc_hd__decap_3
X_2445_ u_parser.u_decoder.timeout_count\[11\] _1174_ net3 VGND VGND VPWR VPWR _1176_
+ sky130_fd_sc_hd__o21ai_1
X_2376_ net480 net459 net15 VGND VGND VPWR VPWR _0302_ sky130_fd_sc_hd__mux2_1
XTAP_TAPCELL_ROW_39_568 VGND VPWR sky130_fd_sc_hd__tapvpwrvgnd_1
XFILLER_17_49 VGND VGND VPWR VPWR sky130_fd_sc_hd__decap_6
XFILLER_24_245 VGND VGND VPWR VPWR sky130_fd_sc_hd__decap_6
XFILLER_33_15 VGND VGND VPWR VPWR sky130_fd_sc_hd__decap_8
XPHY_EDGE_ROW_74_Right_74 VGND VGND VPWR VPWR sky130_fd_sc_hd__decap_3
XTAP_TAPCELL_ROW_22_413 VGND VPWR sky130_fd_sc_hd__tapvpwrvgnd_1
XTAP_TAPCELL_ROW_30_490 VGND VPWR sky130_fd_sc_hd__tapvpwrvgnd_1
XPHY_EDGE_ROW_83_Right_83 VGND VGND VPWR VPWR sky130_fd_sc_hd__decap_3
XFILLER_87_440 VGND VGND VPWR VPWR sky130_fd_sc_hd__fill_2
XFILLER_59_164 VGND VGND VPWR VPWR sky130_fd_sc_hd__decap_4
XFILLER_47_337 VGND VGND VPWR VPWR sky130_fd_sc_hd__decap_8
XFILLER_74_101 VGND VGND VPWR VPWR sky130_fd_sc_hd__decap_3
XFILLER_74_134 VGND VGND VPWR VPWR sky130_fd_sc_hd__decap_6
XPHY_EDGE_ROW_92_Right_92 VGND VGND VPWR VPWR sky130_fd_sc_hd__decap_3
XFILLER_15_223 VGND VGND VPWR VPWR sky130_fd_sc_hd__fill_1
XFILLER_90_65 VGND VGND VPWR VPWR sky130_fd_sc_hd__decap_3
XFILLER_11_473 VPWR VGND VPWR VGND sky130_ef_sc_hd__decap_12
X_2230_ tag_raw\[37\] net487 net54 VGND VGND VPWR VPWR _0234_ sky130_fd_sc_hd__mux2_1
XFILLER_93_421 VPWR VGND VPWR VGND sky130_ef_sc_hd__decap_12
XFILLER_78_473 VGND VGND VPWR VPWR sky130_fd_sc_hd__decap_3
X_2161_ _1029_ _1037_ VGND VGND VPWR VPWR _1038_ sky130_fd_sc_hd__nand2_1
XFILLER_38_315 VGND VGND VPWR VPWR sky130_fd_sc_hd__decap_4
XTAP_TAPCELL_ROW_88_1035 VGND VPWR sky130_fd_sc_hd__tapvpwrvgnd_1
X_2092_ _0968_ _0969_ VGND VGND VPWR VPWR _0970_ sky130_fd_sc_hd__xnor2_2
XFILLER_65_145 VGND VGND VPWR VPWR sky130_fd_sc_hd__fill_1
XFILLER_0_41 VPWR VGND VPWR VGND sky130_ef_sc_hd__decap_12
XTAP_TAPCELL_ROW_64_814 VGND VPWR sky130_fd_sc_hd__tapvpwrvgnd_1
XFILLER_80_137 VGND VGND VPWR VPWR sky130_fd_sc_hd__decap_3
X_2994_ _1499_ _1501_ VGND VGND VPWR VPWR _1502_ sky130_fd_sc_hd__nand2_1
X_1945_ net262 net70 _0943_ VGND VGND VPWR VPWR _0068_ sky130_fd_sc_hd__mux2_1
XFILLER_9_94 VGND VGND VPWR VPWR sky130_fd_sc_hd__fill_1
X_1876_ _0905_ VGND VGND VPWR VPWR _0906_ sky130_fd_sc_hd__inv_2
X_3615_ clknet_leaf_8_clk _0442_ net115 VGND VGND VPWR VPWR u_parser.u_decoder.ascii_buf\[0\]\[2\]
+ sky130_fd_sc_hd__dfrtp_1
X_3546_ clknet_leaf_55_clk _0373_ net99 VGND VGND VPWR VPWR u_parser.u_decoder.decoded_payload\[29\]
+ sky130_fd_sc_hd__dfrtp_1
X_3477_ clknet_leaf_56_clk _0304_ net99 VGND VGND VPWR VPWR tag_raw\[31\] sky130_fd_sc_hd__dfrtp_1
X_2428_ _0787_ _1154_ _1164_ _1151_ net637 VGND VGND VPWR VPWR _0330_ sky130_fd_sc_hd__a32o_1
XFILLER_28_15 VGND VGND VPWR VPWR sky130_fd_sc_hd__decap_4
X_2359_ tag_raw\[12\] net426 net15 VGND VGND VPWR VPWR _0285_ sky130_fd_sc_hd__mux2_1
XFILLER_29_359 VGND VGND VPWR VPWR sky130_fd_sc_hd__decap_8
XFILLER_12_259 VPWR VGND VPWR VGND sky130_ef_sc_hd__decap_12
XFILLER_4_469 VGND VGND VPWR VPWR sky130_fd_sc_hd__decap_6
XFILLER_69_55 VGND VGND VPWR VPWR sky130_fd_sc_hd__fill_1
XFILLER_87_281 VPWR VGND VPWR VGND sky130_ef_sc_hd__decap_12
XFILLER_87_270 VGND VGND VPWR VPWR sky130_fd_sc_hd__decap_8
XTAP_TAPCELL_ROW_78_939 VGND VPWR sky130_fd_sc_hd__tapvpwrvgnd_1
XFILLER_75_498 VGND VGND VPWR VPWR sky130_fd_sc_hd__decap_6
XFILLER_47_156 VGND VGND VPWR VPWR sky130_fd_sc_hd__fill_2
XTAP_TAPCELL_ROW_33_519 VGND VPWR sky130_fd_sc_hd__tapvpwrvgnd_1
XFILLER_11_281 VPWR VGND VPWR VGND sky130_ef_sc_hd__decap_12
X_1730_ u_parser.u_decoder.state\[2\] u_parser.u_decoder.state\[0\] _0709_ VGND VGND
+ VPWR VPWR _0797_ sky130_fd_sc_hd__o21a_2
Xhold208 u_rx_fifo.mem\[1\]\[5\] VGND VGND VPWR VPWR net364 sky130_fd_sc_hd__dlygate4sd3_1
X_1661_ net145 _0727_ VGND VGND VPWR VPWR _0728_ sky130_fd_sc_hd__nor2_1
Xhold219 u_tx_fifo.mem\[10\]\[2\] VGND VGND VPWR VPWR net375 sky130_fd_sc_hd__dlygate4sd3_1
X_3400_ clknet_leaf_55_clk _0233_ net99 VGND VGND VPWR VPWR u_parser.u_packet_encoder.tag_latched\[36\]
+ sky130_fd_sc_hd__dfrtp_1
X_1592_ u_uart_tx.state\[1\] VGND VGND VPWR VPWR _0662_ sky130_fd_sc_hd__inv_2
X_3331_ clknet_leaf_26_clk _0003_ net125 VGND VGND VPWR VPWR u_parser.u_decoder.state\[2\]
+ sky130_fd_sc_hd__dfrtp_1
X_3262_ clknet_leaf_16_clk _0098_ VGND VGND VPWR VPWR u_rx_fifo.mem\[3\]\[5\] sky130_fd_sc_hd__dfxtp_1
X_3193_ clknet_leaf_14_clk _0029_ VGND VGND VPWR VPWR u_rx_fifo.mem\[0\]\[0\] sky130_fd_sc_hd__dfxtp_1
X_2213_ tag_raw\[20\] net522 net51 VGND VGND VPWR VPWR _0217_ sky130_fd_sc_hd__mux2_1
X_2144_ _1020_ _1021_ VGND VGND VPWR VPWR _1022_ sky130_fd_sc_hd__xnor2_2
XTAP_TAPCELL_ROW_49_663 VGND VPWR sky130_fd_sc_hd__tapvpwrvgnd_1
X_2075_ net19 net377 _0962_ VGND VGND VPWR VPWR _0179_ sky130_fd_sc_hd__mux2_1
X_2977_ u_uart_rx.low_count\[14\] _1493_ VGND VGND VPWR VPWR _1496_ sky130_fd_sc_hd__and2_1
X_1928_ net84 net404 _0874_ VGND VGND VPWR VPWR _0053_ sky130_fd_sc_hd__mux2_1
X_1859_ u_tx_fifo.wr_ptr\[0\] u_tx_fifo.wr_ptr\[1\] _0881_ VGND VGND VPWR VPWR _0889_
+ sky130_fd_sc_hd__and3_2
XFILLER_30_27 VGND VGND VPWR VPWR sky130_fd_sc_hd__fill_1
XFILLER_1_417 VPWR VGND VPWR VGND sky130_ef_sc_hd__decap_12
X_3529_ clknet_leaf_39_clk _0356_ net100 VGND VGND VPWR VPWR u_parser.u_decoder.decoded_payload\[12\]
+ sky130_fd_sc_hd__dfrtp_1
XPHY_EDGE_ROW_55_Left_149 VGND VGND VPWR VPWR sky130_fd_sc_hd__decap_3
XFILLER_39_47 VGND VGND VPWR VPWR sky130_fd_sc_hd__fill_1
XTAP_TAPCELL_ROW_4_244 VGND VPWR sky130_fd_sc_hd__tapvpwrvgnd_1
XFILLER_29_134 VGND VGND VPWR VPWR sky130_fd_sc_hd__decap_8
XFILLER_69_281 VPWR VGND VPWR VGND sky130_ef_sc_hd__decap_12
XFILLER_84_251 VGND VGND VPWR VPWR sky130_fd_sc_hd__fill_1
XFILLER_29_167 VGND VGND VPWR VPWR sky130_fd_sc_hd__fill_1
XFILLER_55_57 VGND VGND VPWR VPWR sky130_fd_sc_hd__decap_6
XTAP_TAPCELL_ROW_83_986 VGND VPWR sky130_fd_sc_hd__tapvpwrvgnd_1
XPHY_EDGE_ROW_64_Left_158 VGND VGND VPWR VPWR sky130_fd_sc_hd__decap_3
XFILLER_9_517 VPWR VGND VPWR VGND sky130_ef_sc_hd__decap_12
XFILLER_71_45 VGND VGND VPWR VPWR sky130_fd_sc_hd__fill_1
XPHY_EDGE_ROW_73_Left_167 VGND VGND VPWR VPWR sky130_fd_sc_hd__decap_3
XFILLER_0_461 VPWR VGND VPWR VGND sky130_ef_sc_hd__decap_12
XTAP_TAPCELL_ROW_85_1005 VGND VPWR sky130_fd_sc_hd__tapvpwrvgnd_1
Xhold91 u_tx_fifo.mem\[11\]\[3\] VGND VGND VPWR VPWR net247 sky130_fd_sc_hd__dlygate4sd3_1
XFILLER_48_465 VGND VGND VPWR VPWR sky130_fd_sc_hd__fill_2
Xhold80 u_rx_fifo.mem\[12\]\[6\] VGND VGND VPWR VPWR net236 sky130_fd_sc_hd__dlygate4sd3_1
XFILLER_63_413 VGND VGND VPWR VPWR sky130_fd_sc_hd__decap_8
XPHY_EDGE_ROW_82_Left_176 VGND VGND VPWR VPWR sky130_fd_sc_hd__decap_3
XFILLER_75_284 VGND VGND VPWR VPWR sky130_fd_sc_hd__fill_1
XFILLER_90_243 VGND VGND VPWR VPWR sky130_fd_sc_hd__fill_1
XTAP_TAPCELL_ROW_18_368 VGND VPWR sky130_fd_sc_hd__tapvpwrvgnd_1
X_2900_ net575 _1444_ net6 VGND VGND VPWR VPWR _1447_ sky130_fd_sc_hd__o21ai_1
X_2831_ u_tx_fifo.level\[1\] _1413_ VGND VGND VPWR VPWR _1417_ sky130_fd_sc_hd__nand2_1
XFILLER_77_3 VPWR VGND VPWR VGND sky130_ef_sc_hd__decap_12
X_2762_ u_parser.u_decoder.ascii_buf\[10\]\[0\] u_parser.u_decoder.ascii_buf\[10\]\[1\]
+ u_parser.u_decoder.ascii_buf\[10\]\[2\] _1392_ VGND VGND VPWR VPWR _1393_ sky130_fd_sc_hd__a31oi_1
X_1713_ _0726_ _0734_ net43 net35 VGND VGND VPWR VPWR _0780_ sky130_fd_sc_hd__and4_1
XPHY_EDGE_ROW_91_Left_185 VGND VGND VPWR VPWR sky130_fd_sc_hd__decap_3
X_2693_ _1338_ _1368_ VGND VGND VPWR VPWR _1369_ sky130_fd_sc_hd__xor2_1
X_1644_ u_rx_fifo.mem\[8\]\[3\] u_rx_fifo.mem\[9\]\[3\] u_rx_fifo.mem\[10\]\[3\] u_rx_fifo.mem\[11\]\[3\]
+ net151 net147 VGND VGND VPWR VPWR _0711_ sky130_fd_sc_hd__mux4_1
XFILLER_86_505 VPWR VGND VPWR VGND sky130_ef_sc_hd__decap_12
X_3314_ clknet_leaf_16_clk _0150_ VGND VGND VPWR VPWR u_rx_fifo.mem\[4\]\[1\] sky130_fd_sc_hd__dfxtp_1
X_3245_ clknet_leaf_9_clk _0081_ VGND VGND VPWR VPWR u_rx_fifo.mem\[14\]\[4\] sky130_fd_sc_hd__dfxtp_1
X_3176_ clknet_leaf_26_clk _0012_ net122 VGND VGND VPWR VPWR u_rx_fifo.level\[1\]
+ sky130_fd_sc_hd__dfrtp_1
XTAP_TAPCELL_ROW_1_214 VGND VPWR sky130_fd_sc_hd__tapvpwrvgnd_1
XFILLER_39_476 VPWR VGND VPWR VGND sky130_ef_sc_hd__decap_12
XFILLER_66_251 VGND VGND VPWR VPWR sky130_fd_sc_hd__fill_1
X_2127_ tag_raw\[23\] _0973_ VGND VGND VPWR VPWR _1005_ sky130_fd_sc_hd__xnor2_1
XFILLER_54_435 VGND VGND VPWR VPWR sky130_fd_sc_hd__decap_4
X_2058_ _0890_ _0950_ VGND VGND VPWR VPWR _0960_ sky130_fd_sc_hd__nor2_4
Xclkbuf_leaf_61_clk clknet_3_0__leaf_clk VGND VGND VPWR VPWR clknet_leaf_61_clk sky130_fd_sc_hd__clkbuf_8
XFILLER_41_15 VPWR VGND VPWR VGND sky130_ef_sc_hd__decap_12
XFILLER_1_225 VPWR VGND VPWR VGND sky130_ef_sc_hd__decap_12
XFILLER_1_214 VGND VGND VPWR VPWR sky130_fd_sc_hd__decap_8
XFILLER_89_343 VGND VGND VPWR VPWR sky130_fd_sc_hd__fill_1
XFILLER_72_232 VGND VGND VPWR VPWR sky130_fd_sc_hd__fill_2
XTAP_TAPCELL_ROW_43_614 VGND VPWR sky130_fd_sc_hd__tapvpwrvgnd_1
XFILLER_60_416 VGND VGND VPWR VPWR sky130_fd_sc_hd__decap_4
XFILLER_13_332 VGND VGND VPWR VPWR sky130_fd_sc_hd__decap_4
Xclkbuf_leaf_52_clk clknet_3_2__leaf_clk VGND VGND VPWR VPWR clknet_leaf_52_clk sky130_fd_sc_hd__clkbuf_8
XFILLER_40_173 VGND VGND VPWR VPWR sky130_fd_sc_hd__decap_3
XFILLER_40_195 VGND VGND VPWR VPWR sky130_fd_sc_hd__fill_1
XFILLER_5_553 VGND VGND VPWR VPWR sky130_fd_sc_hd__fill_2
Xoutput2 net2 VGND VGND VPWR VPWR uart_tx_o sky130_fd_sc_hd__buf_2
XTAP_TAPCELL_ROW_91_1064 VGND VPWR sky130_fd_sc_hd__tapvpwrvgnd_1
X_3030_ net226 net77 _1507_ VGND VGND VPWR VPWR _0589_ sky130_fd_sc_hd__mux2_1
XFILLER_83_519 VPWR VGND VPWR VGND sky130_ef_sc_hd__decap_12
XFILLER_48_251 VGND VGND VPWR VPWR sky130_fd_sc_hd__fill_1
XFILLER_91_541 VPWR VGND VPWR VGND sky130_ef_sc_hd__decap_12
XFILLER_63_243 VGND VGND VPWR VPWR sky130_fd_sc_hd__decap_4
Xclkbuf_leaf_43_clk clknet_3_3__leaf_clk VGND VGND VPWR VPWR clknet_leaf_43_clk sky130_fd_sc_hd__clkbuf_8
XFILLER_51_449 VPWR VGND VPWR VGND sky130_ef_sc_hd__decap_12
X_2814_ net499 _0779_ _1411_ VGND VGND VPWR VPWR _0469_ sky130_fd_sc_hd__mux2_1
X_3794_ clknet_leaf_31_clk _0612_ net142 VGND VGND VPWR VPWR u_uart_rx.sample_div_count\[14\]
+ sky130_fd_sc_hd__dfrtp_1
X_2745_ u_parser.u_decoder.ascii_buf\[11\]\[1\] u_parser.u_decoder.ascii_buf\[11\]\[2\]
+ u_parser.u_decoder.ascii_buf\[11\]\[3\] VGND VGND VPWR VPWR _1380_ sky130_fd_sc_hd__o21a_1
X_2676_ _1273_ _1300_ VGND VGND VPWR VPWR _1355_ sky130_fd_sc_hd__xnor2_1
X_1627_ _0689_ _0696_ VGND VGND VPWR VPWR _0697_ sky130_fd_sc_hd__nor2_1
XFILLER_59_549 VGND VGND VPWR VPWR sky130_fd_sc_hd__decap_6
XFILLER_39_240 VGND VGND VPWR VPWR sky130_fd_sc_hd__decap_3
X_3228_ clknet_leaf_11_clk _0064_ VGND VGND VPWR VPWR u_rx_fifo.mem\[10\]\[3\] sky130_fd_sc_hd__dfxtp_1
XFILLER_27_413 VGND VGND VPWR VPWR sky130_fd_sc_hd__decap_4
X_3159_ net178 net26 _1585_ VGND VGND VPWR VPWR _0640_ sky130_fd_sc_hd__mux2_1
XFILLER_36_15 VPWR VGND VPWR VGND sky130_ef_sc_hd__decap_12
XTAP_TAPCELL_ROW_57_739 VGND VPWR sky130_fd_sc_hd__tapvpwrvgnd_1
Xclkbuf_leaf_34_clk clknet_3_6__leaf_clk VGND VGND VPWR VPWR clknet_leaf_34_clk sky130_fd_sc_hd__clkbuf_8
XTAP_TAPCELL_ROW_12_319 VGND VPWR sky130_fd_sc_hd__tapvpwrvgnd_1
XFILLER_10_335 VGND VGND VPWR VPWR sky130_fd_sc_hd__decap_6
XFILLER_10_302 VGND VGND VPWR VPWR sky130_fd_sc_hd__decap_6
XFILLER_10_357 VGND VGND VPWR VPWR sky130_fd_sc_hd__decap_6
XTAP_TAPCELL_ROW_20_396 VGND VPWR sky130_fd_sc_hd__tapvpwrvgnd_1
XFILLER_2_501 VPWR VGND VPWR VGND sky130_ef_sc_hd__decap_12
XFILLER_7_3 VPWR VGND VPWR VGND sky130_ef_sc_hd__decap_12
XFILLER_2_545 VGND VGND VPWR VPWR sky130_fd_sc_hd__decap_8
Xhold380 u_parser.u_packet_encoder.tag_latched\[17\] VGND VGND VPWR VPWR net536 sky130_fd_sc_hd__dlygate4sd3_1
XFILLER_89_173 VGND VGND VPWR VPWR sky130_fd_sc_hd__fill_1
Xhold391 u_uart_rx.rx_shift\[2\] VGND VGND VPWR VPWR net547 sky130_fd_sc_hd__dlygate4sd3_1
XFILLER_77_55 VGND VGND VPWR VPWR sky130_fd_sc_hd__fill_1
XFILLER_77_66 VGND VGND VPWR VPWR sky130_fd_sc_hd__decap_4
XFILLER_92_305 VGND VGND VPWR VPWR sky130_fd_sc_hd__decap_3
XFILLER_45_221 VGND VGND VPWR VPWR sky130_fd_sc_hd__decap_3
XFILLER_73_552 VGND VGND VPWR VPWR sky130_fd_sc_hd__decap_3
XTAP_TAPCELL_ROW_28_463 VGND VPWR sky130_fd_sc_hd__tapvpwrvgnd_1
Xclkbuf_leaf_25_clk clknet_3_7__leaf_clk VGND VGND VPWR VPWR clknet_leaf_25_clk sky130_fd_sc_hd__clkbuf_8
X_2530_ u_parser.u_decoder.ascii_buf\[6\]\[3\] u_parser.u_decoder.ascii_buf\[6\]\[7\]
+ u_parser.u_decoder.ascii_buf\[6\]\[4\] u_parser.u_decoder.ascii_buf\[6\]\[6\] VGND
+ VGND VPWR VPWR _1241_ sky130_fd_sc_hd__or4b_1
X_2461_ u_parser.u_decoder.timeout_count\[15\] _1184_ u_parser.u_decoder.timeout_count\[16\]
+ VGND VGND VPWR VPWR _1187_ sky130_fd_sc_hd__a21o_1
X_2392_ u_parser.u_decoder.ascii_buf\[5\]\[1\] net38 _1144_ VGND VGND VPWR VPWR _0314_
+ sky130_fd_sc_hd__mux2_1
XFILLER_68_324 VGND VGND VPWR VPWR sky130_fd_sc_hd__fill_1
XFILLER_68_357 VGND VGND VPWR VPWR sky130_fd_sc_hd__decap_6
X_3013_ net21 net418 _1505_ VGND VGND VPWR VPWR _0574_ sky130_fd_sc_hd__mux2_1
XFILLER_24_416 VGND VGND VPWR VPWR sky130_fd_sc_hd__decap_4
Xclkbuf_leaf_16_clk clknet_3_5__leaf_clk VGND VGND VPWR VPWR clknet_leaf_16_clk sky130_fd_sc_hd__clkbuf_8
XTAP_TAPCELL_ROW_62_786 VGND VPWR sky130_fd_sc_hd__tapvpwrvgnd_1
X_3777_ clknet_leaf_26_clk _0595_ net124 VGND VGND VPWR VPWR u_uart_rx.sample_phase\[2\]
+ sky130_fd_sc_hd__dfrtp_1
X_2728_ _0718_ u_parser.u_decoder.ascii_buf\[9\]\[3\] _1375_ VGND VGND VPWR VPWR _0419_
+ sky130_fd_sc_hd__mux2_1
X_2659_ _1340_ _1341_ VGND VGND VPWR VPWR _1342_ sky130_fd_sc_hd__xnor2_1
Xfanout112 net113 VGND VGND VPWR VPWR net112 sky130_fd_sc_hd__clkbuf_2
Xfanout101 net114 VGND VGND VPWR VPWR net101 sky130_fd_sc_hd__clkbuf_2
Xfanout123 net125 VGND VGND VPWR VPWR net123 sky130_fd_sc_hd__clkbuf_4
Xfanout145 u_rx_fifo.rd_ptr\[2\] VGND VGND VPWR VPWR net145 sky130_fd_sc_hd__buf_2
Xfanout134 net135 VGND VGND VPWR VPWR net134 sky130_fd_sc_hd__clkbuf_2
XFILLER_74_305 VGND VGND VPWR VPWR sky130_fd_sc_hd__decap_3
XFILLER_47_69 VPWR VGND VPWR VGND sky130_ef_sc_hd__decap_12
XFILLER_55_552 VGND VGND VPWR VPWR sky130_fd_sc_hd__decap_3
XFILLER_67_390 VGND VGND VPWR VPWR sky130_fd_sc_hd__fill_2
XFILLER_82_360 VGND VGND VPWR VPWR sky130_fd_sc_hd__decap_4
XFILLER_15_405 VPWR VGND VPWR VGND sky130_ef_sc_hd__decap_12
XFILLER_27_298 VGND VGND VPWR VPWR sky130_fd_sc_hd__decap_8
XFILLER_63_57 VGND VGND VPWR VPWR sky130_fd_sc_hd__decap_3
XFILLER_70_533 VPWR VGND VPWR VGND sky130_ef_sc_hd__decap_12
XFILLER_30_419 VGND VGND VPWR VPWR sky130_fd_sc_hd__fill_1
XFILLER_23_493 VGND VGND VPWR VPWR sky130_fd_sc_hd__fill_2
XFILLER_6_158 VGND VGND VPWR VPWR sky130_fd_sc_hd__fill_1
XFILLER_12_83 VGND VGND VPWR VPWR sky130_fd_sc_hd__fill_1
XFILLER_88_76 VGND VGND VPWR VPWR sky130_fd_sc_hd__decap_8
XFILLER_77_121 VGND VGND VPWR VPWR sky130_fd_sc_hd__fill_2
XFILLER_65_316 VGND VGND VPWR VPWR sky130_fd_sc_hd__decap_3
XFILLER_18_265 VGND VGND VPWR VPWR sky130_fd_sc_hd__fill_1
XFILLER_18_298 VGND VGND VPWR VPWR sky130_fd_sc_hd__decap_8
XFILLER_33_235 VGND VGND VPWR VPWR sky130_fd_sc_hd__decap_6
X_3700_ clknet_leaf_49_clk _0524_ net102 VGND VGND VPWR VPWR u_uart_tx.clk_count\[7\]
+ sky130_fd_sc_hd__dfrtp_1
X_1961_ net220 net74 _0945_ VGND VGND VPWR VPWR _0082_ sky130_fd_sc_hd__mux2_1
X_1892_ net24 net385 _0892_ VGND VGND VPWR VPWR _0039_ sky130_fd_sc_hd__mux2_1
X_3631_ clknet_leaf_22_clk _0458_ net118 VGND VGND VPWR VPWR u_parser.u_decoder.ascii_buf\[2\]\[2\]
+ sky130_fd_sc_hd__dfrtp_1
X_3562_ clknet_leaf_38_clk _0389_ net127 VGND VGND VPWR VPWR u_parser.u_decoder.decoded_checksum_calc\[5\]
+ sky130_fd_sc_hd__dfrtp_1
X_2513_ u_parser.u_decoder.ascii_buf\[7\]\[0\] u_parser.u_decoder.ascii_buf\[7\]\[1\]
+ u_parser.u_decoder.ascii_buf\[7\]\[2\] _1227_ VGND VGND VPWR VPWR _1228_ sky130_fd_sc_hd__a31oi_1
X_3493_ clknet_leaf_36_clk _0320_ net131 VGND VGND VPWR VPWR u_parser.u_decoder.ascii_buf\[5\]\[7\]
+ sky130_fd_sc_hd__dfrtp_1
XFILLER_88_419 VGND VGND VPWR VPWR sky130_fd_sc_hd__fill_1
Xclkbuf_leaf_5_clk clknet_3_1__leaf_clk VGND VGND VPWR VPWR clknet_leaf_5_clk sky130_fd_sc_hd__clkbuf_8
X_2444_ _1174_ _1175_ VGND VGND VPWR VPWR _0335_ sky130_fd_sc_hd__nor2_1
X_2375_ net506 net500 net15 VGND VGND VPWR VPWR _0301_ sky130_fd_sc_hd__mux2_1
XFILLER_83_113 VGND VGND VPWR VPWR sky130_fd_sc_hd__decap_6
XTAP_TAPCELL_ROW_67_834 VGND VPWR sky130_fd_sc_hd__tapvpwrvgnd_1
XTAP_TAPCELL_ROW_39_569 VGND VPWR sky130_fd_sc_hd__tapvpwrvgnd_1
XFILLER_24_224 VGND VGND VPWR VPWR sky130_fd_sc_hd__fill_1
XFILLER_52_522 VGND VGND VPWR VPWR sky130_fd_sc_hd__fill_1
XTAP_TAPCELL_ROW_22_414 VGND VPWR sky130_fd_sc_hd__tapvpwrvgnd_1
X_3829_ clknet_leaf_7_clk _0645_ VGND VGND VPWR VPWR u_tx_fifo.mem\[0\]\[6\] sky130_fd_sc_hd__dfxtp_1
XTAP_TAPCELL_ROW_30_491 VGND VPWR sky130_fd_sc_hd__tapvpwrvgnd_1
XFILLER_58_57 VGND VGND VPWR VPWR sky130_fd_sc_hd__fill_1
XFILLER_74_67 VGND VGND VPWR VPWR sky130_fd_sc_hd__fill_1
XFILLER_70_341 VPWR VGND VPWR VGND sky130_ef_sc_hd__decap_12
XFILLER_11_485 VPWR VGND VPWR VGND sky130_ef_sc_hd__decap_12
X_2160_ _1035_ _1036_ VGND VGND VPWR VPWR _1037_ sky130_fd_sc_hd__xor2_1
XFILLER_38_305 VGND VGND VPWR VPWR sky130_fd_sc_hd__decap_3
XFILLER_65_113 VGND VGND VPWR VPWR sky130_fd_sc_hd__fill_2
XFILLER_93_433 VPWR VGND VPWR VGND sky130_ef_sc_hd__decap_12
XTAP_TAPCELL_ROW_88_1036 VGND VPWR sky130_fd_sc_hd__tapvpwrvgnd_1
X_2091_ tag_raw\[36\] tag_raw\[28\] VGND VGND VPWR VPWR _0969_ sky130_fd_sc_hd__xor2_1
XFILLER_93_477 VPWR VGND VPWR VGND sky130_ef_sc_hd__decap_12
XFILLER_0_53 VGND VGND VPWR VPWR sky130_fd_sc_hd__decap_3
XFILLER_34_533 VPWR VGND VPWR VGND sky130_ef_sc_hd__decap_12
XTAP_TAPCELL_ROW_36_539 VGND VPWR sky130_fd_sc_hd__tapvpwrvgnd_1
XFILLER_46_371 VPWR VGND VPWR VGND sky130_ef_sc_hd__decap_12
X_2993_ u_uart_tx.bit_index\[0\] u_uart_tx.bit_index\[1\] _0827_ VGND VGND VPWR VPWR
+ _1501_ sky130_fd_sc_hd__a21o_1
XTAP_TAPCELL_ROW_72_881 VGND VPWR sky130_fd_sc_hd__tapvpwrvgnd_1
X_1944_ net253 net72 _0943_ VGND VGND VPWR VPWR _0067_ sky130_fd_sc_hd__mux2_1
X_1875_ u_parser.u_packet_encoder.byte_index\[3\] u_parser.u_packet_encoder.byte_index\[2\]
+ VGND VGND VPWR VPWR _0905_ sky130_fd_sc_hd__or2_2
X_3614_ clknet_leaf_8_clk _0441_ net115 VGND VGND VPWR VPWR u_parser.u_decoder.ascii_buf\[0\]\[1\]
+ sky130_fd_sc_hd__dfrtp_1
X_3545_ clknet_leaf_7_clk _0372_ net96 VGND VGND VPWR VPWR u_parser.u_decoder.decoded_payload\[28\]
+ sky130_fd_sc_hd__dfrtp_1
X_3476_ clknet_leaf_56_clk _0303_ net97 VGND VGND VPWR VPWR tag_raw\[30\] sky130_fd_sc_hd__dfrtp_1
X_2427_ _0673_ _0785_ _0786_ VGND VGND VPWR VPWR _1164_ sky130_fd_sc_hd__or3b_1
X_2358_ tag_raw\[11\] net501 net18 VGND VGND VPWR VPWR _0284_ sky130_fd_sc_hd__mux2_1
XFILLER_84_433 VGND VGND VPWR VPWR sky130_fd_sc_hd__fill_2
X_2289_ u_tx_fifo.mem\[12\]\[3\] u_tx_fifo.mem\[13\]\[3\] u_tx_fifo.mem\[14\]\[3\]
+ u_tx_fifo.mem\[15\]\[3\] net66 net62 VGND VGND VPWR VPWR _1096_ sky130_fd_sc_hd__mux4_1
XFILLER_56_168 VGND VGND VPWR VPWR sky130_fd_sc_hd__fill_1
XFILLER_44_15 VPWR VGND VPWR VGND sky130_ef_sc_hd__decap_12
XFILLER_40_514 VGND VGND VPWR VPWR sky130_fd_sc_hd__fill_2
XFILLER_60_69 VGND VGND VPWR VPWR sky130_fd_sc_hd__decap_6
XTAP_TAPCELL_ROW_7_264 VGND VPWR sky130_fd_sc_hd__tapvpwrvgnd_1
XFILLER_47_113 VPWR VGND VPWR VGND sky130_ef_sc_hd__decap_12
XFILLER_87_293 VGND VGND VPWR VPWR sky130_fd_sc_hd__decap_3
XFILLER_16_533 VPWR VGND VPWR VGND sky130_ef_sc_hd__decap_12
XFILLER_62_127 VGND VGND VPWR VPWR sky130_fd_sc_hd__fill_2
XFILLER_55_190 VGND VGND VPWR VPWR sky130_fd_sc_hd__fill_2
XFILLER_31_525 VPWR VGND VPWR VGND sky130_ef_sc_hd__decap_12
XFILLER_70_160 VPWR VGND VPWR VGND sky130_ef_sc_hd__decap_12
XFILLER_70_193 VGND VGND VPWR VPWR sky130_fd_sc_hd__decap_3
XFILLER_11_293 VGND VGND VPWR VPWR sky130_fd_sc_hd__decap_6
X_1660_ u_rx_fifo.mem\[8\]\[7\] u_rx_fifo.mem\[9\]\[7\] u_rx_fifo.mem\[10\]\[7\] u_rx_fifo.mem\[11\]\[7\]
+ net151 net147 VGND VGND VPWR VPWR _0727_ sky130_fd_sc_hd__mux4_1
X_1591_ u_uart_tx.state\[2\] VGND VGND VPWR VPWR _0661_ sky130_fd_sc_hd__inv_2
Xhold209 u_rx_fifo.mem\[10\]\[1\] VGND VGND VPWR VPWR net365 sky130_fd_sc_hd__dlygate4sd3_1
X_3330_ clknet_leaf_24_clk _0000_ net128 VGND VGND VPWR VPWR u_parser.u_decoder.state\[1\]
+ sky130_fd_sc_hd__dfrtp_1
X_3261_ clknet_leaf_15_clk _0097_ VGND VGND VPWR VPWR u_rx_fifo.mem\[3\]\[4\] sky130_fd_sc_hd__dfxtp_1
X_3192_ clknet_leaf_15_clk _0028_ VGND VGND VPWR VPWR u_rx_fifo.mem\[6\]\[7\] sky130_fd_sc_hd__dfxtp_1
X_2212_ tag_raw\[19\] net528 net56 VGND VGND VPWR VPWR _0216_ sky130_fd_sc_hd__mux2_1
XFILLER_22_3 VGND VGND VPWR VPWR sky130_fd_sc_hd__fill_2
X_2143_ tag_raw\[18\] _0984_ VGND VGND VPWR VPWR _1021_ sky130_fd_sc_hd__xnor2_1
XTAP_TAPCELL_ROW_49_664 VGND VPWR sky130_fd_sc_hd__tapvpwrvgnd_1
XFILLER_66_477 VGND VGND VPWR VPWR sky130_fd_sc_hd__decap_3
XFILLER_81_436 VGND VGND VPWR VPWR sky130_fd_sc_hd__fill_1
XFILLER_19_393 VGND VGND VPWR VPWR sky130_fd_sc_hd__decap_4
X_2074_ net22 net284 _0962_ VGND VGND VPWR VPWR _0178_ sky130_fd_sc_hd__mux2_1
XFILLER_34_330 VGND VGND VPWR VPWR sky130_fd_sc_hd__fill_1
XFILLER_34_363 VGND VGND VPWR VPWR sky130_fd_sc_hd__fill_1
X_2976_ u_uart_rx.low_count\[14\] _1493_ VGND VGND VPWR VPWR _1495_ sky130_fd_sc_hd__nor2_1
X_1927_ net173 net71 _0941_ VGND VGND VPWR VPWR _0052_ sky130_fd_sc_hd__mux2_1
X_1858_ net376 net70 _0888_ VGND VGND VPWR VPWR _0036_ sky130_fd_sc_hd__mux2_1
Xfanout3 _1156_ VGND VGND VPWR VPWR net3 sky130_fd_sc_hd__clkbuf_2
X_1789_ _0710_ _0815_ VGND VGND VPWR VPWR _0846_ sky130_fd_sc_hd__or2_2
XFILLER_1_429 VPWR VGND VPWR VGND sky130_ef_sc_hd__decap_12
XFILLER_39_15 VPWR VGND VPWR VGND sky130_ef_sc_hd__decap_12
X_3528_ clknet_leaf_36_clk _0355_ net130 VGND VGND VPWR VPWR u_parser.u_decoder.decoded_payload\[11\]
+ sky130_fd_sc_hd__dfrtp_1
X_3459_ clknet_leaf_39_clk _0286_ net106 VGND VGND VPWR VPWR tag_raw\[13\] sky130_fd_sc_hd__dfrtp_1
XFILLER_57_400 VPWR VGND VPWR VGND sky130_ef_sc_hd__decap_12
XFILLER_69_271 VGND VGND VPWR VPWR sky130_fd_sc_hd__decap_8
XFILLER_57_433 VPWR VGND VPWR VGND sky130_ef_sc_hd__decap_12
XFILLER_69_293 VPWR VGND VPWR VGND sky130_ef_sc_hd__decap_12
XFILLER_29_157 VGND VGND VPWR VPWR sky130_fd_sc_hd__fill_1
XFILLER_37_190 VGND VGND VPWR VPWR sky130_fd_sc_hd__fill_2
XTAP_TAPCELL_ROW_83_987 VGND VPWR sky130_fd_sc_hd__tapvpwrvgnd_1
XFILLER_52_193 VGND VGND VPWR VPWR sky130_fd_sc_hd__decap_3
XFILLER_9_529 VPWR VGND VPWR VGND sky130_ef_sc_hd__decap_12
XFILLER_71_79 VGND VGND VPWR VPWR sky130_fd_sc_hd__decap_8
XFILLER_4_267 VGND VGND VPWR VPWR sky130_fd_sc_hd__fill_2
XFILLER_20_50 VGND VGND VPWR VPWR sky130_fd_sc_hd__decap_6
XFILLER_0_473 VGND VGND VPWR VPWR sky130_fd_sc_hd__decap_3
Xhold70 u_rx_fifo.mem\[2\]\[4\] VGND VGND VPWR VPWR net226 sky130_fd_sc_hd__dlygate4sd3_1
Xhold92 u_rx_fifo.mem\[2\]\[5\] VGND VGND VPWR VPWR net248 sky130_fd_sc_hd__dlygate4sd3_1
Xhold81 u_tx_fifo.mem\[12\]\[5\] VGND VGND VPWR VPWR net237 sky130_fd_sc_hd__dlygate4sd3_1
XTAP_TAPCELL_ROW_85_1006 VGND VPWR sky130_fd_sc_hd__tapvpwrvgnd_1
XTAP_TAPCELL_ROW_46_634 VGND VPWR sky130_fd_sc_hd__tapvpwrvgnd_1
XTAP_TAPCELL_ROW_18_369 VGND VPWR sky130_fd_sc_hd__tapvpwrvgnd_1
X_2830_ u_tx_fifo.level\[1\] _1413_ VGND VGND VPWR VPWR _1416_ sky130_fd_sc_hd__or2_1
XFILLER_31_344 VGND VGND VPWR VPWR sky130_fd_sc_hd__fill_1
X_2761_ u_parser.u_decoder.ascii_buf\[10\]\[3\] u_parser.u_decoder.ascii_buf\[10\]\[7\]
+ u_parser.u_decoder.ascii_buf\[10\]\[4\] u_parser.u_decoder.ascii_buf\[10\]\[6\]
+ VGND VGND VPWR VPWR _1392_ sky130_fd_sc_hd__or4b_1
X_2692_ _1250_ _1279_ VGND VGND VPWR VPWR _1368_ sky130_fd_sc_hd__xnor2_1
X_1712_ _0773_ _0775_ _0778_ _0671_ VGND VGND VPWR VPWR _0779_ sky130_fd_sc_hd__a22o_2
XFILLER_6_41 VGND VGND VPWR VPWR sky130_fd_sc_hd__decap_4
XANTENNA_1 _0718_ VGND VGND VPWR VPWR sky130_fd_sc_hd__diode_2
X_1643_ u_parser.u_decoder.state\[2\] _0709_ VGND VGND VPWR VPWR _0710_ sky130_fd_sc_hd__nand2_1
XFILLER_6_85 VGND VGND VPWR VPWR sky130_fd_sc_hd__fill_2
X_3313_ clknet_leaf_14_clk _0149_ VGND VGND VPWR VPWR u_rx_fifo.mem\[4\]\[0\] sky130_fd_sc_hd__dfxtp_1
XFILLER_86_517 VPWR VGND VPWR VGND sky130_ef_sc_hd__decap_12
XFILLER_39_400 VGND VGND VPWR VPWR sky130_fd_sc_hd__fill_2
XFILLER_39_411 VPWR VGND VPWR VGND sky130_ef_sc_hd__decap_12
X_3244_ clknet_leaf_10_clk _0080_ VGND VGND VPWR VPWR u_rx_fifo.mem\[14\]\[3\] sky130_fd_sc_hd__dfxtp_1
X_3175_ clknet_leaf_26_clk _0011_ net122 VGND VGND VPWR VPWR u_rx_fifo.level\[0\]
+ sky130_fd_sc_hd__dfrtp_1
XTAP_TAPCELL_ROW_1_215 VGND VPWR sky130_fd_sc_hd__tapvpwrvgnd_1
X_2126_ _0990_ _0999_ VGND VGND VPWR VPWR _1004_ sky130_fd_sc_hd__xnor2_4
XFILLER_39_488 VPWR VGND VPWR VGND sky130_ef_sc_hd__decap_12
X_2057_ net179 net71 _0959_ VGND VGND VPWR VPWR _0164_ sky130_fd_sc_hd__mux2_1
XFILLER_41_108 VGND VGND VPWR VPWR sky130_fd_sc_hd__decap_4
XTAP_TAPCELL_ROW_80_957 VGND VPWR sky130_fd_sc_hd__tapvpwrvgnd_1
XFILLER_41_27 VPWR VGND VPWR VGND sky130_ef_sc_hd__decap_12
X_2959_ net86 _1482_ _1483_ VGND VGND VPWR VPWR _0542_ sky130_fd_sc_hd__nor3_1
XFILLER_1_237 VGND VGND VPWR VPWR sky130_fd_sc_hd__fill_1
XFILLER_77_539 VGND VGND VPWR VPWR sky130_fd_sc_hd__fill_1
XFILLER_77_528 VGND VGND VPWR VPWR sky130_fd_sc_hd__fill_2
XFILLER_49_219 VGND VGND VPWR VPWR sky130_fd_sc_hd__decap_4
XFILLER_66_79 VGND VGND VPWR VPWR sky130_fd_sc_hd__decap_4
XFILLER_72_299 VGND VGND VPWR VPWR sky130_fd_sc_hd__fill_1
XFILLER_9_337 VGND VGND VPWR VPWR sky130_fd_sc_hd__fill_1
XFILLER_9_326 VGND VGND VPWR VPWR sky130_fd_sc_hd__fill_2
XTAP_TAPCELL_ROW_91_1065 VGND VPWR sky130_fd_sc_hd__tapvpwrvgnd_1
XFILLER_36_414 VGND VGND VPWR VPWR sky130_fd_sc_hd__decap_6
XFILLER_63_200 VGND VGND VPWR VPWR sky130_fd_sc_hd__decap_4
XFILLER_91_553 VGND VGND VPWR VPWR sky130_fd_sc_hd__fill_2
X_2813_ net545 _0743_ _1411_ VGND VGND VPWR VPWR _0468_ sky130_fd_sc_hd__mux2_1
X_3793_ clknet_leaf_31_clk _0611_ net142 VGND VGND VPWR VPWR u_uart_rx.sample_div_count\[13\]
+ sky130_fd_sc_hd__dfrtp_1
X_2744_ u_parser.u_decoder.ascii_buf\[11\]\[0\] u_parser.u_decoder.ascii_buf\[11\]\[1\]
+ u_parser.u_decoder.ascii_buf\[11\]\[2\] u_parser.u_decoder.ascii_buf\[11\]\[3\]
+ _1378_ VGND VGND VPWR VPWR _1379_ sky130_fd_sc_hd__o41a_1
X_2675_ u_parser.u_decoder.decoded_checksum_calc\[3\] _1354_ net13 VGND VGND VPWR
+ VPWR _0387_ sky130_fd_sc_hd__mux2_1
X_1626_ _0692_ _0693_ _0694_ VGND VGND VPWR VPWR _0696_ sky130_fd_sc_hd__or3_1
XFILLER_86_325 VGND VGND VPWR VPWR sky130_fd_sc_hd__fill_1
X_3227_ clknet_leaf_11_clk _0063_ VGND VGND VPWR VPWR u_rx_fifo.mem\[10\]\[2\] sky130_fd_sc_hd__dfxtp_1
XFILLER_74_509 VGND VGND VPWR VPWR sky130_fd_sc_hd__fill_1
XFILLER_82_520 VGND VGND VPWR VPWR sky130_fd_sc_hd__decap_8
X_3158_ net207 net28 _1585_ VGND VGND VPWR VPWR _0639_ sky130_fd_sc_hd__mux2_1
XFILLER_36_27 VGND VGND VPWR VPWR sky130_fd_sc_hd__fill_1
XFILLER_82_553 VGND VGND VPWR VPWR sky130_fd_sc_hd__fill_2
X_2109_ _0985_ _0986_ VGND VGND VPWR VPWR _0987_ sky130_fd_sc_hd__xnor2_2
X_3089_ u_uart_rx.sample_div_count\[11\] u_uart_rx.sample_div_count\[12\] _1543_ VGND
+ VGND VPWR VPWR _1546_ sky130_fd_sc_hd__and3_1
XFILLER_52_15 VPWR VGND VPWR VGND sky130_ef_sc_hd__decap_12
XFILLER_2_513 VPWR VGND VPWR VGND sky130_ef_sc_hd__decap_12
Xhold381 u_parser.u_packet_encoder.tag_latched\[36\] VGND VGND VPWR VPWR net537 sky130_fd_sc_hd__dlygate4sd3_1
Xhold370 u_parser.u_decoder.ascii_buf\[5\]\[7\] VGND VGND VPWR VPWR net526 sky130_fd_sc_hd__dlygate4sd3_1
XFILLER_89_152 VGND VGND VPWR VPWR sky130_fd_sc_hd__decap_6
Xhold392 u_parser.u_decoder.ascii_buf\[1\]\[4\] VGND VGND VPWR VPWR net548 sky130_fd_sc_hd__dlygate4sd3_1
XFILLER_92_328 VPWR VGND VPWR VGND sky130_ef_sc_hd__decap_12
XFILLER_92_317 VGND VGND VPWR VPWR sky130_fd_sc_hd__fill_1
XTAP_TAPCELL_ROW_28_464 VGND VPWR sky130_fd_sc_hd__tapvpwrvgnd_1
X_2460_ u_parser.u_decoder.timeout_count\[15\] _1184_ _1186_ VGND VGND VPWR VPWR _0340_
+ sky130_fd_sc_hd__o21a_1
XFILLER_3_31 VGND VGND VPWR VPWR sky130_fd_sc_hd__fill_1
X_2391_ u_parser.u_decoder.ascii_buf\[5\]\[0\] net41 _1144_ VGND VGND VPWR VPWR _0313_
+ sky130_fd_sc_hd__mux2_1
X_3012_ net31 net350 _1505_ VGND VGND VPWR VPWR _0573_ sky130_fd_sc_hd__mux2_1
XFILLER_64_531 VGND VGND VPWR VPWR sky130_fd_sc_hd__fill_1
XFILLER_64_553 VGND VGND VPWR VPWR sky130_fd_sc_hd__fill_2
XFILLER_91_350 VGND VGND VPWR VPWR sky130_fd_sc_hd__fill_2
XFILLER_17_491 VGND VGND VPWR VPWR sky130_fd_sc_hd__decap_4
XTAP_TAPCELL_ROW_62_787 VGND VPWR sky130_fd_sc_hd__tapvpwrvgnd_1
X_3776_ clknet_leaf_28_clk _0594_ net138 VGND VGND VPWR VPWR u_uart_rx.sample_phase\[1\]
+ sky130_fd_sc_hd__dfrtp_1
X_2727_ net37 net428 _1375_ VGND VGND VPWR VPWR _0418_ sky130_fd_sc_hd__mux2_1
X_2658_ _1286_ _1339_ VGND VGND VPWR VPWR _1341_ sky130_fd_sc_hd__xnor2_1
Xfanout102 net113 VGND VGND VPWR VPWR net102 sky130_fd_sc_hd__clkbuf_4
Xfanout113 net114 VGND VGND VPWR VPWR net113 sky130_fd_sc_hd__buf_2
X_2589_ u_parser.u_decoder.ascii_buf\[3\]\[5\] _1284_ _1285_ _1282_ VGND VGND VPWR
+ VPWR _1287_ sky130_fd_sc_hd__a211o_1
X_1609_ u_parser.u_decoder.decoded_checksum_rx\[4\] VGND VGND VPWR VPWR _0679_ sky130_fd_sc_hd__inv_2
Xfanout124 net125 VGND VGND VPWR VPWR net124 sky130_fd_sc_hd__buf_2
Xfanout146 u_rx_fifo.rd_ptr\[2\] VGND VGND VPWR VPWR net146 sky130_fd_sc_hd__buf_2
Xfanout135 net157 VGND VGND VPWR VPWR net135 sky130_fd_sc_hd__clkbuf_2
XFILLER_47_15 VPWR VGND VPWR VGND sky130_ef_sc_hd__decap_12
XFILLER_15_417 VGND VGND VPWR VPWR sky130_fd_sc_hd__fill_2
XFILLER_27_288 VGND VGND VPWR VPWR sky130_fd_sc_hd__decap_3
XFILLER_70_545 VGND VGND VPWR VPWR sky130_fd_sc_hd__decap_8
XFILLER_6_115 VGND VGND VPWR VPWR sky130_fd_sc_hd__fill_1
XFILLER_2_365 VPWR VGND VPWR VGND sky130_ef_sc_hd__decap_12
XFILLER_77_188 VGND VGND VPWR VPWR sky130_fd_sc_hd__decap_3
XFILLER_92_125 VGND VGND VPWR VPWR sky130_fd_sc_hd__fill_1
XFILLER_92_136 VGND VGND VPWR VPWR sky130_fd_sc_hd__decap_4
XFILLER_80_309 VGND VGND VPWR VPWR sky130_fd_sc_hd__decap_8
XFILLER_46_553 VGND VGND VPWR VPWR sky130_fd_sc_hd__fill_2
XFILLER_73_350 VGND VGND VPWR VPWR sky130_fd_sc_hd__fill_1
XFILLER_33_225 VGND VGND VPWR VPWR sky130_fd_sc_hd__fill_1
X_1960_ net296 net76 _0945_ VGND VGND VPWR VPWR _0081_ sky130_fd_sc_hd__mux2_1
X_1891_ _0915_ _0918_ VGND VGND VPWR VPWR _0919_ sky130_fd_sc_hd__or2_2
X_3630_ clknet_leaf_22_clk _0457_ net118 VGND VGND VPWR VPWR u_parser.u_decoder.ascii_buf\[2\]\[1\]
+ sky130_fd_sc_hd__dfrtp_1
X_3561_ clknet_leaf_38_clk _0388_ net127 VGND VGND VPWR VPWR u_parser.u_decoder.decoded_checksum_calc\[4\]
+ sky130_fd_sc_hd__dfrtp_1
XFILLER_52_3 VPWR VGND VPWR VGND sky130_ef_sc_hd__decap_12
X_2512_ u_parser.u_decoder.ascii_buf\[7\]\[3\] u_parser.u_decoder.ascii_buf\[7\]\[4\]
+ u_parser.u_decoder.ascii_buf\[7\]\[7\] u_parser.u_decoder.ascii_buf\[7\]\[6\] VGND
+ VGND VPWR VPWR _1227_ sky130_fd_sc_hd__or4b_1
X_3492_ clknet_leaf_36_clk _0319_ net131 VGND VGND VPWR VPWR u_parser.u_decoder.ascii_buf\[5\]\[6\]
+ sky130_fd_sc_hd__dfrtp_1
X_2443_ u_parser.u_decoder.timeout_count\[10\] _1172_ net3 VGND VGND VPWR VPWR _1175_
+ sky130_fd_sc_hd__o21ai_1
X_2374_ tag_raw\[27\] net455 net18 VGND VGND VPWR VPWR _0300_ sky130_fd_sc_hd__mux2_1
XFILLER_68_133 VGND VGND VPWR VPWR sky130_fd_sc_hd__decap_6
XFILLER_68_155 VGND VGND VPWR VPWR sky130_fd_sc_hd__fill_1
XTAP_TAPCELL_ROW_67_835 VGND VPWR sky130_fd_sc_hd__tapvpwrvgnd_1
XFILLER_83_136 VGND VGND VPWR VPWR sky130_fd_sc_hd__decap_6
XFILLER_37_531 VPWR VGND VPWR VGND sky130_ef_sc_hd__decap_12
XFILLER_83_169 VGND VGND VPWR VPWR sky130_fd_sc_hd__decap_6
XFILLER_24_269 VGND VGND VPWR VPWR sky130_fd_sc_hd__fill_1
XTAP_TAPCELL_ROW_22_415 VGND VPWR sky130_fd_sc_hd__tapvpwrvgnd_1
X_3828_ clknet_leaf_58_clk _0644_ VGND VGND VPWR VPWR u_tx_fifo.mem\[0\]\[5\] sky130_fd_sc_hd__dfxtp_1
X_3759_ clknet_leaf_12_clk _0577_ VGND VGND VPWR VPWR u_rx_fifo.mem\[9\]\[0\] sky130_fd_sc_hd__dfxtp_1
XFILLER_87_420 VGND VGND VPWR VPWR sky130_fd_sc_hd__fill_1
XFILLER_59_111 VGND VGND VPWR VPWR sky130_fd_sc_hd__fill_1
XFILLER_28_531 VGND VGND VPWR VPWR sky130_fd_sc_hd__fill_1
XFILLER_28_553 VGND VGND VPWR VPWR sky130_fd_sc_hd__fill_2
XFILLER_62_309 VGND VGND VPWR VPWR sky130_fd_sc_hd__decap_4
XFILLER_15_225 VGND VGND VPWR VPWR sky130_fd_sc_hd__fill_1
XFILLER_70_353 VGND VGND VPWR VPWR sky130_fd_sc_hd__decap_8
XPHY_EDGE_ROW_4_Left_98 VGND VGND VPWR VPWR sky130_fd_sc_hd__decap_3
XFILLER_11_497 VGND VGND VPWR VPWR sky130_fd_sc_hd__decap_6
XFILLER_2_173 VGND VGND VPWR VPWR sky130_fd_sc_hd__fill_2
XFILLER_78_486 VPWR VGND VPWR VGND sky130_ef_sc_hd__decap_12
XFILLER_93_445 VGND VGND VPWR VPWR sky130_fd_sc_hd__decap_3
XTAP_TAPCELL_ROW_88_1037 VGND VPWR sky130_fd_sc_hd__tapvpwrvgnd_1
X_2090_ tag_raw\[35\] tag_raw\[34\] VGND VGND VPWR VPWR _0968_ sky130_fd_sc_hd__xnor2_2
XFILLER_93_489 VPWR VGND VPWR VGND sky130_ef_sc_hd__decap_12
XFILLER_46_361 VGND VGND VPWR VPWR sky130_fd_sc_hd__decap_3
XTAP_TAPCELL_ROW_64_805 VGND VPWR sky130_fd_sc_hd__tapvpwrvgnd_1
XFILLER_0_65 VPWR VGND VPWR VGND sky130_ef_sc_hd__decap_12
XFILLER_46_383 VGND VGND VPWR VPWR sky130_fd_sc_hd__fill_1
XFILLER_34_545 VGND VGND VPWR VPWR sky130_fd_sc_hd__decap_8
XFILLER_61_331 VGND VGND VPWR VPWR sky130_fd_sc_hd__decap_4
X_2992_ u_uart_tx.bit_index\[0\] _0829_ _1500_ VGND VGND VPWR VPWR _0558_ sky130_fd_sc_hd__o21a_1
XTAP_TAPCELL_ROW_72_882 VGND VPWR sky130_fd_sc_hd__tapvpwrvgnd_1
X_1943_ net285 net74 _0943_ VGND VGND VPWR VPWR _0066_ sky130_fd_sc_hd__mux2_1
X_1874_ u_parser.u_packet_encoder.byte_index\[2\] _0895_ u_parser.u_packet_encoder.byte_index\[3\]
+ VGND VGND VPWR VPWR _0904_ sky130_fd_sc_hd__o21ai_4
X_3613_ clknet_leaf_8_clk _0440_ net115 VGND VGND VPWR VPWR u_parser.u_decoder.ascii_buf\[0\]\[0\]
+ sky130_fd_sc_hd__dfrtp_1
X_3544_ clknet_leaf_36_clk _0371_ net130 VGND VGND VPWR VPWR u_parser.u_decoder.decoded_payload\[27\]
+ sky130_fd_sc_hd__dfrtp_1
XFILLER_88_206 VGND VGND VPWR VPWR sky130_fd_sc_hd__decap_4
X_3475_ clknet_leaf_55_clk _0302_ net100 VGND VGND VPWR VPWR tag_raw\[29\] sky130_fd_sc_hd__dfrtp_1
X_2426_ u_parser.u_decoder.timeout_count\[3\] u_parser.u_decoder.timeout_count\[5\]
+ u_parser.u_decoder.timeout_count\[4\] _0786_ VGND VGND VPWR VPWR _1163_ sky130_fd_sc_hd__and4_1
X_2357_ net502 net476 net17 VGND VGND VPWR VPWR _0283_ sky130_fd_sc_hd__mux2_1
X_2288_ u_tx_fifo.mem\[8\]\[3\] u_tx_fifo.mem\[9\]\[3\] u_tx_fifo.mem\[10\]\[3\] u_tx_fifo.mem\[11\]\[3\]
+ net67 net63 VGND VGND VPWR VPWR _1095_ sky130_fd_sc_hd__mux4_1
XFILLER_25_501 VGND VGND VPWR VPWR sky130_fd_sc_hd__decap_3
XFILLER_56_158 VGND VGND VPWR VPWR sky130_fd_sc_hd__fill_1
XFILLER_71_128 VGND VGND VPWR VPWR sky130_fd_sc_hd__decap_4
XFILLER_44_27 VGND VGND VPWR VPWR sky130_fd_sc_hd__fill_1
XFILLER_12_217 VGND VGND VPWR VPWR sky130_fd_sc_hd__decap_8
XFILLER_60_15 VPWR VGND VPWR VGND sky130_ef_sc_hd__decap_12
XFILLER_69_57 VGND VGND VPWR VPWR sky130_fd_sc_hd__decap_4
XTAP_TAPCELL_ROW_7_265 VGND VPWR sky130_fd_sc_hd__tapvpwrvgnd_1
XFILLER_47_125 VPWR VGND VPWR VGND sky130_ef_sc_hd__decap_12
XFILLER_85_78 VGND VGND VPWR VPWR sky130_fd_sc_hd__fill_1
XFILLER_18_94 VPWR VGND VPWR VGND sky130_ef_sc_hd__decap_12
XFILLER_28_372 VGND VGND VPWR VPWR sky130_fd_sc_hd__decap_4
XFILLER_16_545 VGND VGND VPWR VPWR sky130_fd_sc_hd__decap_8
XFILLER_70_172 VGND VGND VPWR VPWR sky130_fd_sc_hd__decap_4
XFILLER_31_537 VPWR VGND VPWR VGND sky130_ef_sc_hd__decap_12
XFILLER_11_261 VPWR VGND VPWR VGND sky130_ef_sc_hd__decap_12
XTAP_TAPCELL_ROW_41_587 VGND VPWR sky130_fd_sc_hd__tapvpwrvgnd_1
X_1590_ u_tx_fifo.level\[4\] VGND VGND VPWR VPWR _0660_ sky130_fd_sc_hd__inv_2
X_3260_ clknet_leaf_14_clk _0096_ VGND VGND VPWR VPWR u_rx_fifo.mem\[3\]\[3\] sky130_fd_sc_hd__dfxtp_1
X_3191_ clknet_leaf_14_clk _0027_ VGND VGND VPWR VPWR u_rx_fifo.mem\[6\]\[6\] sky130_fd_sc_hd__dfxtp_1
X_2211_ tag_raw\[18\] net518 net55 VGND VGND VPWR VPWR _0215_ sky130_fd_sc_hd__mux2_1
XTAP_TAPCELL_ROW_77_930 VGND VPWR sky130_fd_sc_hd__tapvpwrvgnd_1
XFILLER_15_3 VGND VGND VPWR VPWR sky130_fd_sc_hd__decap_4
X_2142_ _0992_ _1014_ VGND VGND VPWR VPWR _1020_ sky130_fd_sc_hd__xnor2_2
XFILLER_38_114 VGND VGND VPWR VPWR sky130_fd_sc_hd__fill_1
XFILLER_93_253 VPWR VGND VPWR VGND sky130_ef_sc_hd__decap_12
XFILLER_81_404 VPWR VGND VPWR VGND sky130_ef_sc_hd__decap_12
X_2073_ net31 net267 _0962_ VGND VGND VPWR VPWR _0177_ sky130_fd_sc_hd__mux2_1
XFILLER_26_309 VGND VGND VPWR VPWR sky130_fd_sc_hd__decap_6
XTAP_TAPCELL_ROW_49_665 VGND VPWR sky130_fd_sc_hd__tapvpwrvgnd_1
XFILLER_66_456 VGND VGND VPWR VPWR sky130_fd_sc_hd__fill_1
XFILLER_22_515 VPWR VGND VPWR VGND sky130_ef_sc_hd__decap_12
XFILLER_61_161 VGND VGND VPWR VPWR sky130_fd_sc_hd__decap_6
XTAP_TAPCELL_ROW_32_510 VGND VPWR sky130_fd_sc_hd__tapvpwrvgnd_1
X_2975_ net86 _1493_ _1494_ VGND VGND VPWR VPWR _0547_ sky130_fd_sc_hd__nor3b_1
X_1926_ net322 net73 _0941_ VGND VGND VPWR VPWR _0051_ sky130_fd_sc_hd__mux2_1
X_1857_ net261 net73 _0888_ VGND VGND VPWR VPWR _0035_ sky130_fd_sc_hd__mux2_1
Xfanout4 _1156_ VGND VGND VPWR VPWR net4 sky130_fd_sc_hd__buf_1
X_1788_ _0845_ VGND VGND VPWR VPWR _0010_ sky130_fd_sc_hd__inv_2
X_3527_ clknet_leaf_46_clk _0354_ net105 VGND VGND VPWR VPWR u_parser.u_decoder.decoded_payload\[10\]
+ sky130_fd_sc_hd__dfrtp_1
XFILLER_39_27 VPWR VGND VPWR VGND sky130_ef_sc_hd__decap_12
X_3458_ clknet_leaf_40_clk _0285_ net100 VGND VGND VPWR VPWR tag_raw\[12\] sky130_fd_sc_hd__dfrtp_1
XFILLER_76_209 VGND VGND VPWR VPWR sky130_fd_sc_hd__decap_6
X_3389_ clknet_leaf_46_clk _0222_ net104 VGND VGND VPWR VPWR u_parser.u_packet_encoder.tag_latched\[25\]
+ sky130_fd_sc_hd__dfrtp_1
X_2409_ u_parser.u_decoder.state\[1\] _0817_ VGND VGND VPWR VPWR _1151_ sky130_fd_sc_hd__nor2_1
XTAP_TAPCELL_ROW_4_235 VGND VPWR sky130_fd_sc_hd__tapvpwrvgnd_1
XFILLER_29_125 VGND VGND VPWR VPWR sky130_fd_sc_hd__fill_1
XFILLER_57_445 VGND VGND VPWR VPWR sky130_fd_sc_hd__decap_3
XFILLER_55_15 VPWR VGND VPWR VGND sky130_ef_sc_hd__decap_12
XFILLER_44_117 VGND VGND VPWR VPWR sky130_fd_sc_hd__decap_6
XTAP_TAPCELL_ROW_83_988 VGND VPWR sky130_fd_sc_hd__tapvpwrvgnd_1
XFILLER_4_246 VGND VGND VPWR VPWR sky130_fd_sc_hd__fill_1
Xhold82 u_rx_fifo.mem\[6\]\[6\] VGND VGND VPWR VPWR net238 sky130_fd_sc_hd__dlygate4sd3_1
Xhold71 u_rx_fifo.mem\[4\]\[5\] VGND VGND VPWR VPWR net227 sky130_fd_sc_hd__dlygate4sd3_1
XFILLER_29_93 VGND VGND VPWR VPWR sky130_fd_sc_hd__fill_1
Xhold60 u_rx_fifo.mem\[8\]\[6\] VGND VGND VPWR VPWR net216 sky130_fd_sc_hd__dlygate4sd3_1
XTAP_TAPCELL_ROW_74_900 VGND VPWR sky130_fd_sc_hd__tapvpwrvgnd_1
XTAP_TAPCELL_ROW_85_1007 VGND VPWR sky130_fd_sc_hd__tapvpwrvgnd_1
Xhold93 u_tx_fifo.mem\[7\]\[5\] VGND VGND VPWR VPWR net249 sky130_fd_sc_hd__dlygate4sd3_1
XFILLER_75_297 VPWR VGND VPWR VGND sky130_ef_sc_hd__decap_12
XFILLER_28_191 VGND VGND VPWR VPWR sky130_fd_sc_hd__decap_4
XTAP_TAPCELL_ROW_46_635 VGND VPWR sky130_fd_sc_hd__tapvpwrvgnd_1
XFILLER_45_81 VPWR VGND VPWR VGND sky130_ef_sc_hd__decap_12
XFILLER_50_109 VPWR VGND VPWR VGND sky130_ef_sc_hd__decap_12
X_2760_ u_parser.u_decoder.decoded_checksum_rx\[3\] _1391_ net13 VGND VGND VPWR VPWR
+ _0435_ sky130_fd_sc_hd__mux2_1
X_1711_ _0776_ _0777_ _0670_ VGND VGND VPWR VPWR _0778_ sky130_fd_sc_hd__mux2_1
X_2691_ _1221_ _1307_ VGND VGND VPWR VPWR _1367_ sky130_fd_sc_hd__xor2_1
XANTENNA_2 net43 VGND VGND VPWR VPWR sky130_fd_sc_hd__diode_2
X_1642_ u_rx_fifo.level\[4\] _0707_ VGND VGND VPWR VPWR _0709_ sky130_fd_sc_hd__or2_1
X_3312_ clknet_leaf_0_clk _0148_ VGND VGND VPWR VPWR u_tx_fifo.mem\[13\]\[7\] sky130_fd_sc_hd__dfxtp_1
XFILLER_86_529 VGND VGND VPWR VPWR sky130_fd_sc_hd__decap_3
X_3243_ clknet_leaf_10_clk _0079_ VGND VGND VPWR VPWR u_rx_fifo.mem\[14\]\[2\] sky130_fd_sc_hd__dfxtp_1
XFILLER_39_423 VGND VGND VPWR VPWR sky130_fd_sc_hd__decap_4
X_3174_ net30 net289 _1586_ VGND VGND VPWR VPWR _0654_ sky130_fd_sc_hd__mux2_1
XFILLER_66_253 VGND VGND VPWR VPWR sky130_fd_sc_hd__fill_1
XFILLER_26_106 VGND VGND VPWR VPWR sky130_fd_sc_hd__decap_4
X_2125_ _0988_ _1002_ VGND VGND VPWR VPWR _1003_ sky130_fd_sc_hd__xnor2_2
X_2056_ net236 net73 _0959_ VGND VGND VPWR VPWR _0163_ sky130_fd_sc_hd__mux2_1
XFILLER_22_301 VGND VGND VPWR VPWR sky130_fd_sc_hd__decap_6
XTAP_TAPCELL_ROW_80_958 VGND VPWR sky130_fd_sc_hd__tapvpwrvgnd_1
XFILLER_34_183 VPWR VGND VPWR VGND sky130_ef_sc_hd__decap_12
XFILLER_22_389 VGND VGND VPWR VPWR sky130_fd_sc_hd__decap_6
XFILLER_41_39 VPWR VGND VPWR VGND sky130_ef_sc_hd__decap_12
X_2958_ u_uart_rx.low_count\[7\] u_uart_rx.low_count\[8\] _1480_ VGND VGND VPWR VPWR
+ _1483_ sky130_fd_sc_hd__and3_1
X_1909_ u_parser.u_packet_encoder.tag_latched\[14\] _0894_ VGND VGND VPWR VPWR _0933_
+ sky130_fd_sc_hd__and2_1
X_2889_ _0661_ u_uart_tx.clk_count\[0\] VGND VGND VPWR VPWR _1439_ sky130_fd_sc_hd__and2_1
XFILLER_57_220 VGND VGND VPWR VPWR sky130_fd_sc_hd__decap_4
XFILLER_57_253 VPWR VGND VPWR VGND sky130_ef_sc_hd__decap_12
XFILLER_40_120 VGND VGND VPWR VPWR sky130_fd_sc_hd__fill_1
XFILLER_13_389 VGND VGND VPWR VPWR sky130_fd_sc_hd__decap_3
XFILLER_40_164 VGND VGND VPWR VPWR sky130_fd_sc_hd__fill_1
XTAP_TAPCELL_ROW_51_682 VGND VPWR sky130_fd_sc_hd__tapvpwrvgnd_1
XFILLER_40_197 VPWR VGND VPWR VGND sky130_ef_sc_hd__decap_12
XTAP_TAPCELL_ROW_91_1066 VGND VPWR sky130_fd_sc_hd__tapvpwrvgnd_1
XFILLER_48_253 VGND VGND VPWR VPWR sky130_fd_sc_hd__fill_2
XTAP_TAPCELL_ROW_59_760 VGND VPWR sky130_fd_sc_hd__tapvpwrvgnd_1
XFILLER_63_278 VGND VGND VPWR VPWR sky130_fd_sc_hd__fill_2
X_3792_ clknet_leaf_31_clk _0610_ net138 VGND VGND VPWR VPWR u_uart_rx.sample_div_count\[12\]
+ sky130_fd_sc_hd__dfrtp_1
XFILLER_82_3 VPWR VGND VPWR VGND sky130_ef_sc_hd__decap_12
X_2812_ u_parser.u_decoder.ascii_buf\[3\]\[3\] _0718_ _1411_ VGND VGND VPWR VPWR _0467_
+ sky130_fd_sc_hd__mux2_1
X_2743_ u_parser.u_decoder.ascii_buf\[11\]\[0\] u_parser.u_decoder.ascii_buf\[11\]\[1\]
+ u_parser.u_decoder.ascii_buf\[11\]\[2\] _1377_ VGND VGND VPWR VPWR _1378_ sky130_fd_sc_hd__a31oi_1
X_2674_ _1351_ _1353_ VGND VGND VPWR VPWR _1354_ sky130_fd_sc_hd__xnor2_1
X_1625_ _0692_ _0693_ _0694_ VGND VGND VPWR VPWR _0695_ sky130_fd_sc_hd__or3_1
XFILLER_86_304 VGND VGND VPWR VPWR sky130_fd_sc_hd__decap_4
XFILLER_86_359 VGND VGND VPWR VPWR sky130_fd_sc_hd__decap_4
X_3226_ clknet_leaf_13_clk _0062_ VGND VGND VPWR VPWR u_rx_fifo.mem\[10\]\[1\] sky130_fd_sc_hd__dfxtp_1
XPHY_EDGE_ROW_6_Left_100 VGND VGND VPWR VPWR sky130_fd_sc_hd__decap_3
X_3157_ _0950_ _0961_ VGND VGND VPWR VPWR _1585_ sky130_fd_sc_hd__nor2_4
X_2108_ tag_raw\[20\] _0970_ VGND VGND VPWR VPWR _0986_ sky130_fd_sc_hd__xnor2_1
X_3088_ _1545_ _1544_ u_uart_rx.sample_div_count\[11\] VGND VGND VPWR VPWR _0609_
+ sky130_fd_sc_hd__mux2_1
X_2039_ net29 net212 _0957_ VGND VGND VPWR VPWR _0148_ sky130_fd_sc_hd__mux2_1
XFILLER_52_27 VGND VGND VPWR VPWR sky130_fd_sc_hd__fill_1
XFILLER_22_153 VGND VGND VPWR VPWR sky130_fd_sc_hd__decap_3
XFILLER_50_462 VPWR VGND VPWR VGND sky130_ef_sc_hd__decap_12
XTAP_TAPCELL_ROW_20_387 VGND VPWR sky130_fd_sc_hd__tapvpwrvgnd_1
XFILLER_89_131 VGND VGND VPWR VPWR sky130_fd_sc_hd__decap_4
Xhold371 u_uart_rx.rx_shift\[6\] VGND VGND VPWR VPWR net527 sky130_fd_sc_hd__dlygate4sd3_1
XFILLER_2_525 VGND VGND VPWR VPWR sky130_fd_sc_hd__decap_6
Xhold360 u_parser.u_packet_encoder.tag_latched\[27\] VGND VGND VPWR VPWR net516 sky130_fd_sc_hd__dlygate4sd3_1
Xhold382 u_parser.u_packet_encoder.tag_latched\[2\] VGND VGND VPWR VPWR net538 sky130_fd_sc_hd__dlygate4sd3_1
Xhold393 u_parser.u_decoder.decoded_checksum_rx\[7\] VGND VGND VPWR VPWR net549 sky130_fd_sc_hd__dlygate4sd3_1
XTAP_TAPCELL_ROW_56_730 VGND VPWR sky130_fd_sc_hd__tapvpwrvgnd_1
XFILLER_73_532 VPWR VGND VPWR VGND sky130_ef_sc_hd__decap_12
XFILLER_26_50 VGND VGND VPWR VPWR sky130_fd_sc_hd__decap_8
XTAP_TAPCELL_ROW_28_465 VGND VPWR sky130_fd_sc_hd__tapvpwrvgnd_1
XFILLER_9_102 VGND VGND VPWR VPWR sky130_fd_sc_hd__fill_2
XTAP_TAPCELL_ROW_11_310 VGND VPWR sky130_fd_sc_hd__tapvpwrvgnd_1
X_2390_ _1142_ _1143_ VGND VGND VPWR VPWR _1144_ sky130_fd_sc_hd__nor2_2
XPHY_EDGE_ROW_79_Left_173 VGND VGND VPWR VPWR sky130_fd_sc_hd__decap_3
XFILLER_49_540 VPWR VGND VPWR VGND sky130_ef_sc_hd__decap_12
X_3011_ net33 net270 _1505_ VGND VGND VPWR VPWR _0572_ sky130_fd_sc_hd__mux2_1
XFILLER_36_201 VGND VGND VPWR VPWR sky130_fd_sc_hd__fill_1
XFILLER_24_429 VGND VGND VPWR VPWR sky130_fd_sc_hd__fill_2
XPHY_EDGE_ROW_88_Left_182 VGND VGND VPWR VPWR sky130_fd_sc_hd__decap_3
XFILLER_32_473 VGND VGND VPWR VPWR sky130_fd_sc_hd__decap_3
XTAP_TAPCELL_ROW_62_788 VGND VPWR sky130_fd_sc_hd__tapvpwrvgnd_1
X_3775_ clknet_leaf_26_clk _0593_ net124 VGND VGND VPWR VPWR u_uart_rx.sample_phase\[0\]
+ sky130_fd_sc_hd__dfrtp_1
X_2726_ net39 u_parser.u_decoder.ascii_buf\[9\]\[1\] _1375_ VGND VGND VPWR VPWR _0417_
+ sky130_fd_sc_hd__mux2_1
X_2657_ _1230_ _1257_ VGND VGND VPWR VPWR _1340_ sky130_fd_sc_hd__xnor2_1
X_1608_ u_parser.u_decoder.decoded_checksum_calc\[3\] VGND VGND VPWR VPWR _0678_ sky130_fd_sc_hd__inv_2
Xfanout103 net113 VGND VGND VPWR VPWR net103 sky130_fd_sc_hd__clkbuf_2
X_2588_ net435 _1286_ net11 VGND VGND VPWR VPWR _0368_ sky130_fd_sc_hd__mux2_1
Xfanout125 net126 VGND VGND VPWR VPWR net125 sky130_fd_sc_hd__clkbuf_2
Xfanout114 net157 VGND VGND VPWR VPWR net114 sky130_fd_sc_hd__buf_2
XFILLER_59_337 VGND VGND VPWR VPWR sky130_fd_sc_hd__fill_1
Xfanout147 u_rx_fifo.rd_ptr\[1\] VGND VGND VPWR VPWR net147 sky130_fd_sc_hd__clkbuf_4
Xfanout136 net144 VGND VGND VPWR VPWR net136 sky130_fd_sc_hd__clkbuf_4
XFILLER_47_27 VPWR VGND VPWR VGND sky130_ef_sc_hd__decap_12
X_3209_ clknet_leaf_21_clk _0045_ VGND VGND VPWR VPWR u_rx_fifo.mem\[13\]\[0\] sky130_fd_sc_hd__dfxtp_1
XFILLER_27_223 VGND VGND VPWR VPWR sky130_fd_sc_hd__fill_1
XFILLER_63_15 VPWR VGND VPWR VGND sky130_ef_sc_hd__decap_12
XFILLER_42_237 VGND VGND VPWR VPWR sky130_fd_sc_hd__decap_4
XTAP_TAPCELL_ROW_25_435 VGND VPWR sky130_fd_sc_hd__tapvpwrvgnd_1
XFILLER_10_189 VGND VGND VPWR VPWR sky130_fd_sc_hd__decap_6
XFILLER_12_85 VGND VGND VPWR VPWR sky130_fd_sc_hd__decap_4
XFILLER_88_67 VGND VGND VPWR VPWR sky130_fd_sc_hd__fill_1
Xhold190 u_rx_fifo.mem\[5\]\[5\] VGND VGND VPWR VPWR net346 sky130_fd_sc_hd__dlygate4sd3_1
XFILLER_2_377 VPWR VGND VPWR VGND sky130_ef_sc_hd__decap_12
XFILLER_77_178 VGND VGND VPWR VPWR sky130_fd_sc_hd__fill_1
XFILLER_18_212 VPWR VGND VPWR VGND sky130_ef_sc_hd__decap_12
XPHY_EDGE_ROW_16_Right_16 VGND VGND VPWR VPWR sky130_fd_sc_hd__decap_3
XFILLER_37_82 VGND VGND VPWR VPWR sky130_fd_sc_hd__decap_4
X_1890_ u_parser.u_packet_encoder.tag_latched\[34\] _0896_ _0903_ u_parser.u_packet_encoder.crc_latched\[2\]
+ _0917_ VGND VGND VPWR VPWR _0918_ sky130_fd_sc_hd__a221o_1
XFILLER_41_281 VGND VGND VPWR VPWR sky130_fd_sc_hd__fill_2
XFILLER_41_292 VGND VGND VPWR VPWR sky130_fd_sc_hd__decap_6
XPHY_EDGE_ROW_25_Right_25 VGND VGND VPWR VPWR sky130_fd_sc_hd__decap_3
X_3560_ clknet_leaf_36_clk _0387_ net131 VGND VGND VPWR VPWR u_parser.u_decoder.decoded_checksum_calc\[3\]
+ sky130_fd_sc_hd__dfrtp_1
X_2511_ u_parser.u_decoder.ascii_buf\[7\]\[0\] _1224_ VGND VGND VPWR VPWR _1226_ sky130_fd_sc_hd__nand2_1
X_3491_ clknet_leaf_43_clk _0318_ net111 VGND VGND VPWR VPWR u_parser.u_decoder.ascii_buf\[5\]\[5\]
+ sky130_fd_sc_hd__dfrtp_1
XFILLER_5_193 VPWR VGND VPWR VGND sky130_ef_sc_hd__decap_12
XFILLER_45_3 VPWR VGND VPWR VGND sky130_ef_sc_hd__decap_12
X_2442_ u_parser.u_decoder.timeout_count\[10\] _1172_ VGND VGND VPWR VPWR _1174_ sky130_fd_sc_hd__and2_1
X_2373_ tag_raw\[26\] net471 net17 VGND VGND VPWR VPWR _0299_ sky130_fd_sc_hd__mux2_1
XPHY_EDGE_ROW_34_Right_34 VGND VGND VPWR VPWR sky130_fd_sc_hd__decap_3
XFILLER_37_543 VPWR VGND VPWR VGND sky130_ef_sc_hd__decap_12
XTAP_TAPCELL_ROW_67_836 VGND VPWR sky130_fd_sc_hd__tapvpwrvgnd_1
XFILLER_20_421 VGND VGND VPWR VPWR sky130_fd_sc_hd__decap_8
X_3827_ clknet_leaf_58_clk _0643_ VGND VGND VPWR VPWR u_tx_fifo.mem\[0\]\[4\] sky130_fd_sc_hd__dfxtp_1
XPHY_EDGE_ROW_43_Right_43 VGND VGND VPWR VPWR sky130_fd_sc_hd__decap_3
X_3758_ clknet_leaf_0_clk _0576_ VGND VGND VPWR VPWR u_tx_fifo.mem\[15\]\[7\] sky130_fd_sc_hd__dfxtp_1
XTAP_TAPCELL_ROW_30_482 VGND VPWR sky130_fd_sc_hd__tapvpwrvgnd_1
X_2709_ net36 u_parser.u_decoder.ascii_buf\[10\]\[2\] _1373_ VGND VGND VPWR VPWR _0402_
+ sky130_fd_sc_hd__mux2_1
XFILLER_3_119 VGND VGND VPWR VPWR sky130_fd_sc_hd__fill_1
X_3689_ clknet_leaf_6_clk _0516_ VGND VGND VPWR VPWR u_tx_fifo.mem\[1\]\[7\] sky130_fd_sc_hd__dfxtp_1
XFILLER_58_15 VPWR VGND VPWR VGND sky130_ef_sc_hd__decap_12
XFILLER_59_101 VGND VGND VPWR VPWR sky130_fd_sc_hd__fill_1
XPHY_EDGE_ROW_52_Right_52 VGND VGND VPWR VPWR sky130_fd_sc_hd__decap_3
XTAP_TAPCELL_ROW_38_560 VGND VPWR sky130_fd_sc_hd__tapvpwrvgnd_1
XFILLER_70_365 VGND VGND VPWR VPWR sky130_fd_sc_hd__fill_1
XFILLER_11_421 VPWR VGND VPWR VGND sky130_ef_sc_hd__decap_12
XFILLER_23_281 VGND VGND VPWR VPWR sky130_fd_sc_hd__decap_6
XPHY_EDGE_ROW_61_Right_61 VGND VGND VPWR VPWR sky130_fd_sc_hd__decap_3
XFILLER_7_447 VGND VGND VPWR VPWR sky130_fd_sc_hd__fill_1
XFILLER_78_421 VGND VGND VPWR VPWR sky130_fd_sc_hd__fill_1
XPHY_EDGE_ROW_70_Right_70 VGND VGND VPWR VPWR sky130_fd_sc_hd__decap_3
XTAP_TAPCELL_ROW_88_1038 VGND VPWR sky130_fd_sc_hd__tapvpwrvgnd_1
XFILLER_78_498 VPWR VGND VPWR VGND sky130_ef_sc_hd__decap_12
XTAP_TAPCELL_ROW_64_806 VGND VPWR sky130_fd_sc_hd__tapvpwrvgnd_1
XFILLER_0_77 VGND VGND VPWR VPWR sky130_fd_sc_hd__decap_6
X_2991_ _0662_ u_uart_tx.bit_index\[0\] _1499_ VGND VGND VPWR VPWR _1500_ sky130_fd_sc_hd__o21ai_1
XTAP_TAPCELL_ROW_72_883 VGND VPWR sky130_fd_sc_hd__tapvpwrvgnd_1
XFILLER_14_270 VGND VGND VPWR VPWR sky130_fd_sc_hd__fill_1
XFILLER_9_53 VGND VGND VPWR VPWR sky130_fd_sc_hd__decap_3
X_1942_ net348 net76 _0943_ VGND VGND VPWR VPWR _0065_ sky130_fd_sc_hd__mux2_1
X_1873_ u_parser.u_packet_encoder.byte_index\[2\] _0895_ u_parser.u_packet_encoder.byte_index\[3\]
+ VGND VGND VPWR VPWR _0903_ sky130_fd_sc_hd__o21a_1
XFILLER_9_75 VGND VGND VPWR VPWR sky130_fd_sc_hd__fill_2
X_3612_ clknet_leaf_38_clk _0439_ net127 VGND VGND VPWR VPWR u_parser.u_decoder.decoded_checksum_rx\[7\]
+ sky130_fd_sc_hd__dfrtp_1
X_3543_ clknet_leaf_45_clk _0370_ net110 VGND VGND VPWR VPWR u_parser.u_decoder.decoded_payload\[26\]
+ sky130_fd_sc_hd__dfrtp_1
X_3474_ clknet_leaf_56_clk _0301_ net96 VGND VGND VPWR VPWR tag_raw\[28\] sky130_fd_sc_hd__dfrtp_1
X_2425_ _0785_ _1160_ _1162_ net3 VGND VGND VPWR VPWR _0329_ sky130_fd_sc_hd__o211a_1
XFILLER_69_432 VPWR VGND VPWR VGND sky130_ef_sc_hd__decap_12
X_2356_ tag_raw\[9\] net453 net17 VGND VGND VPWR VPWR _0282_ sky130_fd_sc_hd__mux2_1
XFILLER_28_29 VGND VGND VPWR VPWR sky130_fd_sc_hd__fill_2
X_2287_ _1092_ _1093_ net61 VGND VGND VPWR VPWR _1094_ sky130_fd_sc_hd__mux2_1
XTAP_TAPCELL_ROW_35_530 VGND VPWR sky130_fd_sc_hd__tapvpwrvgnd_1
XFILLER_52_365 VGND VGND VPWR VPWR sky130_fd_sc_hd__decap_6
XFILLER_60_27 VGND VGND VPWR VPWR sky130_fd_sc_hd__fill_1
Xclkbuf_3_0__f_clk clknet_0_clk VGND VGND VPWR VPWR clknet_3_0__leaf_clk sky130_fd_sc_hd__clkbuf_16
XTAP_TAPCELL_ROW_7_266 VGND VPWR sky130_fd_sc_hd__tapvpwrvgnd_1
XFILLER_47_137 VPWR VGND VPWR VGND sky130_ef_sc_hd__decap_12
XFILLER_28_340 VGND VGND VPWR VPWR sky130_fd_sc_hd__fill_2
XFILLER_16_513 VGND VGND VPWR VPWR sky130_fd_sc_hd__decap_4
XFILLER_28_362 VGND VGND VPWR VPWR sky130_fd_sc_hd__fill_2
XFILLER_31_549 VGND VGND VPWR VPWR sky130_fd_sc_hd__decap_6
XFILLER_11_273 VGND VGND VPWR VPWR sky130_fd_sc_hd__decap_6
XTAP_TAPCELL_ROW_41_588 VGND VPWR sky130_fd_sc_hd__tapvpwrvgnd_1
XFILLER_7_233 VGND VGND VPWR VPWR sky130_fd_sc_hd__decap_6
XFILLER_3_461 VPWR VGND VPWR VGND sky130_ef_sc_hd__decap_12
X_2210_ net437 net536 net55 VGND VGND VPWR VPWR _0214_ sky130_fd_sc_hd__mux2_1
X_3190_ clknet_leaf_16_clk _0026_ VGND VGND VPWR VPWR u_rx_fifo.mem\[6\]\[5\] sky130_fd_sc_hd__dfxtp_1
XFILLER_93_221 VGND VGND VPWR VPWR sky130_fd_sc_hd__decap_3
XTAP_TAPCELL_ROW_77_931 VGND VPWR sky130_fd_sc_hd__tapvpwrvgnd_1
X_2141_ tag_raw\[12\] _0987_ VGND VGND VPWR VPWR _1019_ sky130_fd_sc_hd__xnor2_1
XFILLER_93_265 VPWR VGND VPWR VGND sky130_ef_sc_hd__decap_12
X_2072_ net33 net290 _0962_ VGND VGND VPWR VPWR _0176_ sky130_fd_sc_hd__mux2_1
XTAP_TAPCELL_ROW_49_666 VGND VPWR sky130_fd_sc_hd__tapvpwrvgnd_1
XFILLER_81_416 VPWR VGND VPWR VGND sky130_ef_sc_hd__decap_12
XFILLER_34_365 VGND VGND VPWR VPWR sky130_fd_sc_hd__decap_4
XFILLER_61_151 VGND VGND VPWR VPWR sky130_fd_sc_hd__fill_2
X_2974_ _0668_ _0844_ _1492_ u_uart_rx.low_count\[13\] VGND VGND VPWR VPWR _1494_
+ sky130_fd_sc_hd__a31o_1
XFILLER_22_527 VGND VGND VPWR VPWR sky130_fd_sc_hd__decap_4
XFILLER_34_387 VGND VGND VPWR VPWR sky130_fd_sc_hd__fill_1
X_1925_ net280 net74 _0941_ VGND VGND VPWR VPWR _0050_ sky130_fd_sc_hd__mux2_1
X_1856_ net175 net75 _0888_ VGND VGND VPWR VPWR _0034_ sky130_fd_sc_hd__mux2_1
XPHY_EDGE_ROW_15_Left_109 VGND VGND VPWR VPWR sky130_fd_sc_hd__decap_3
X_1787_ u_uart_rx.vote_ones\[1\] _0001_ VGND VGND VPWR VPWR _0845_ sky130_fd_sc_hd__nand2_4
XFILLER_89_505 VPWR VGND VPWR VGND sky130_ef_sc_hd__decap_12
X_3526_ clknet_leaf_45_clk _0353_ net110 VGND VGND VPWR VPWR u_parser.u_decoder.decoded_payload\[9\]
+ sky130_fd_sc_hd__dfrtp_1
XFILLER_39_39 VGND VGND VPWR VPWR sky130_fd_sc_hd__decap_8
X_3457_ clknet_leaf_38_clk _0284_ net127 VGND VGND VPWR VPWR tag_raw\[11\] sky130_fd_sc_hd__dfrtp_1
X_3388_ clknet_leaf_42_clk _0221_ net109 VGND VGND VPWR VPWR u_parser.u_packet_encoder.tag_latched\[24\]
+ sky130_fd_sc_hd__dfrtp_1
X_2408_ _0784_ _1146_ _1150_ VGND VGND VPWR VPWR _0324_ sky130_fd_sc_hd__o21a_1
XTAP_TAPCELL_ROW_4_236 VGND VPWR sky130_fd_sc_hd__tapvpwrvgnd_1
XPHY_EDGE_ROW_24_Left_118 VGND VGND VPWR VPWR sky130_fd_sc_hd__decap_3
X_2339_ net155 _0803_ _0807_ _0809_ VGND VGND VPWR VPWR _1133_ sky130_fd_sc_hd__and4_1
XPHY_EDGE_ROW_2_Right_2 VGND VGND VPWR VPWR sky130_fd_sc_hd__decap_3
XFILLER_55_27 VPWR VGND VPWR VGND sky130_ef_sc_hd__decap_12
XFILLER_72_405 VGND VGND VPWR VPWR sky130_fd_sc_hd__fill_2
Xclkbuf_leaf_64_clk clknet_3_0__leaf_clk VGND VGND VPWR VPWR clknet_leaf_64_clk sky130_fd_sc_hd__clkbuf_8
XTAP_TAPCELL_ROW_83_989 VGND VPWR sky130_fd_sc_hd__tapvpwrvgnd_1
XFILLER_13_505 VPWR VGND VPWR VGND sky130_ef_sc_hd__decap_12
XFILLER_25_354 VGND VGND VPWR VPWR sky130_fd_sc_hd__decap_6
XFILLER_40_302 VGND VGND VPWR VPWR sky130_fd_sc_hd__decap_6
XFILLER_71_15 VPWR VGND VPWR VGND sky130_ef_sc_hd__decap_12
XPHY_EDGE_ROW_33_Left_127 VGND VGND VPWR VPWR sky130_fd_sc_hd__decap_3
XFILLER_20_85 VGND VGND VPWR VPWR sky130_fd_sc_hd__fill_2
XPHY_EDGE_ROW_42_Left_136 VGND VGND VPWR VPWR sky130_fd_sc_hd__decap_3
Xhold50 u_tx_fifo.mem\[0\]\[2\] VGND VGND VPWR VPWR net206 sky130_fd_sc_hd__dlygate4sd3_1
XFILLER_48_413 VGND VGND VPWR VPWR sky130_fd_sc_hd__decap_6
Xhold83 u_rx_fifo.mem\[4\]\[3\] VGND VGND VPWR VPWR net239 sky130_fd_sc_hd__dlygate4sd3_1
Xhold72 u_tx_fifo.mem\[7\]\[0\] VGND VGND VPWR VPWR net228 sky130_fd_sc_hd__dlygate4sd3_1
Xhold61 u_rx_fifo.mem\[8\]\[2\] VGND VGND VPWR VPWR net217 sky130_fd_sc_hd__dlygate4sd3_1
XTAP_TAPCELL_ROW_85_1008 VGND VPWR sky130_fd_sc_hd__tapvpwrvgnd_1
Xhold94 u_tx_fifo.mem\[13\]\[3\] VGND VGND VPWR VPWR net250 sky130_fd_sc_hd__dlygate4sd3_1
XTAP_TAPCELL_ROW_74_901 VGND VPWR sky130_fd_sc_hd__tapvpwrvgnd_1
Xclkbuf_leaf_55_clk clknet_3_3__leaf_clk VGND VGND VPWR VPWR clknet_leaf_55_clk sky130_fd_sc_hd__clkbuf_8
XTAP_TAPCELL_ROW_46_636 VGND VPWR sky130_fd_sc_hd__tapvpwrvgnd_1
XFILLER_63_449 VGND VGND VPWR VPWR sky130_fd_sc_hd__fill_2
XFILLER_16_365 VPWR VGND VPWR VGND sky130_ef_sc_hd__decap_12
XFILLER_31_335 VGND VGND VPWR VPWR sky130_fd_sc_hd__fill_1
XFILLER_45_93 VPWR VGND VPWR VGND sky130_ef_sc_hd__decap_12
XPHY_EDGE_ROW_51_Left_145 VGND VGND VPWR VPWR sky130_fd_sc_hd__decap_3
XFILLER_8_531 VGND VGND VPWR VPWR sky130_fd_sc_hd__fill_1
X_1710_ u_rx_fifo.mem\[0\]\[5\] u_rx_fifo.mem\[1\]\[5\] u_rx_fifo.mem\[2\]\[5\] u_rx_fifo.mem\[3\]\[5\]
+ net154 net150 VGND VGND VPWR VPWR _0777_ sky130_fd_sc_hd__mux4_1
XFILLER_8_553 VGND VGND VPWR VPWR sky130_fd_sc_hd__fill_2
X_2690_ net598 _1366_ net8 VGND VGND VPWR VPWR _0390_ sky130_fd_sc_hd__mux2_1
XFILLER_61_92 VGND VGND VPWR VPWR sky130_fd_sc_hd__decap_4
X_1641_ u_rx_fifo.level\[4\] _0707_ VGND VGND VPWR VPWR _0708_ sky130_fd_sc_hd__nor2_1
X_3311_ clknet_leaf_66_clk _0147_ VGND VGND VPWR VPWR u_tx_fifo.mem\[13\]\[6\] sky130_fd_sc_hd__dfxtp_1
XPHY_EDGE_ROW_60_Left_154 VGND VGND VPWR VPWR sky130_fd_sc_hd__decap_3
X_3242_ clknet_leaf_21_clk _0078_ VGND VGND VPWR VPWR u_rx_fifo.mem\[14\]\[1\] sky130_fd_sc_hd__dfxtp_1
X_3173_ net20 net337 _1586_ VGND VGND VPWR VPWR _0653_ sky130_fd_sc_hd__mux2_1
X_2124_ tag_raw\[14\] _1001_ VGND VGND VPWR VPWR _1002_ sky130_fd_sc_hd__xnor2_1
XFILLER_81_202 VGND VGND VPWR VPWR sky130_fd_sc_hd__decap_3
XFILLER_19_181 VGND VGND VPWR VPWR sky130_fd_sc_hd__decap_6
Xclkbuf_leaf_46_clk clknet_3_2__leaf_clk VGND VGND VPWR VPWR clknet_leaf_46_clk sky130_fd_sc_hd__clkbuf_8
X_2055_ net187 net74 _0959_ VGND VGND VPWR VPWR _0162_ sky130_fd_sc_hd__mux2_1
XFILLER_81_279 VGND VGND VPWR VPWR sky130_fd_sc_hd__fill_1
XTAP_TAPCELL_ROW_80_959 VGND VPWR sky130_fd_sc_hd__tapvpwrvgnd_1
XTAP_TAPCELL_ROW_17_360 VGND VPWR sky130_fd_sc_hd__tapvpwrvgnd_1
XFILLER_34_195 VGND VGND VPWR VPWR sky130_fd_sc_hd__fill_1
X_2957_ u_uart_rx.low_count\[7\] _1480_ u_uart_rx.low_count\[8\] VGND VGND VPWR VPWR
+ _1482_ sky130_fd_sc_hd__a21oi_1
X_1908_ net22 net249 _0892_ VGND VGND VPWR VPWR _0042_ sky130_fd_sc_hd__mux2_1
X_2888_ net30 net378 _1438_ VGND VGND VPWR VPWR _0516_ sky130_fd_sc_hd__mux2_1
X_1839_ _0873_ _0884_ VGND VGND VPWR VPWR _0885_ sky130_fd_sc_hd__nor2_4
XFILLER_89_335 VGND VGND VPWR VPWR sky130_fd_sc_hd__fill_1
X_3509_ clknet_leaf_33_clk _0336_ net136 VGND VGND VPWR VPWR u_parser.u_decoder.timeout_count\[11\]
+ sky130_fd_sc_hd__dfrtp_1
XFILLER_66_15 VPWR VGND VPWR VGND sky130_ef_sc_hd__decap_12
XFILLER_85_541 VPWR VGND VPWR VGND sky130_ef_sc_hd__decap_12
XFILLER_57_265 VPWR VGND VPWR VGND sky130_ef_sc_hd__decap_12
XFILLER_72_213 VGND VGND VPWR VPWR sky130_fd_sc_hd__decap_3
XFILLER_45_449 VGND VGND VPWR VPWR sky130_fd_sc_hd__fill_1
Xclkbuf_leaf_37_clk clknet_3_6__leaf_clk VGND VGND VPWR VPWR clknet_leaf_37_clk sky130_fd_sc_hd__clkbuf_8
XTAP_TAPCELL_ROW_43_606 VGND VPWR sky130_fd_sc_hd__tapvpwrvgnd_1
XFILLER_80_290 VPWR VGND VPWR VGND sky130_ef_sc_hd__decap_12
XFILLER_9_317 VGND VGND VPWR VPWR sky130_fd_sc_hd__fill_1
XTAP_TAPCELL_ROW_51_683 VGND VPWR sky130_fd_sc_hd__tapvpwrvgnd_1
XTAP_TAPCELL_ROW_91_1067 VGND VPWR sky130_fd_sc_hd__tapvpwrvgnd_1
XFILLER_36_405 VGND VGND VPWR VPWR sky130_fd_sc_hd__fill_1
XTAP_TAPCELL_ROW_59_761 VGND VPWR sky130_fd_sc_hd__tapvpwrvgnd_1
Xclkbuf_leaf_28_clk clknet_3_7__leaf_clk VGND VGND VPWR VPWR clknet_leaf_28_clk sky130_fd_sc_hd__clkbuf_8
XFILLER_16_184 VGND VGND VPWR VPWR sky130_fd_sc_hd__fill_1
XTAP_TAPCELL_ROW_14_330 VGND VPWR sky130_fd_sc_hd__tapvpwrvgnd_1
X_3791_ clknet_leaf_31_clk _0609_ net138 VGND VGND VPWR VPWR u_uart_rx.sample_div_count\[11\]
+ sky130_fd_sc_hd__dfrtp_1
X_2811_ u_parser.u_decoder.ascii_buf\[3\]\[2\] net37 _1411_ VGND VGND VPWR VPWR _0466_
+ sky130_fd_sc_hd__mux2_1
X_2742_ u_parser.u_decoder.ascii_buf\[11\]\[3\] u_parser.u_decoder.ascii_buf\[11\]\[4\]
+ u_parser.u_decoder.ascii_buf\[11\]\[7\] u_parser.u_decoder.ascii_buf\[11\]\[6\]
+ VGND VGND VPWR VPWR _1377_ sky130_fd_sc_hd__or4b_1
XFILLER_75_3 VPWR VGND VPWR VGND sky130_ef_sc_hd__decap_12
X_2673_ _1323_ _1352_ VGND VGND VPWR VPWR _1353_ sky130_fd_sc_hd__xnor2_1
X_1624_ u_uart_rx.sample_div_count\[13\] u_uart_rx.sample_div_count\[12\] u_uart_rx.sample_div_count\[15\]
+ u_uart_rx.sample_div_count\[14\] VGND VGND VPWR VPWR _0694_ sky130_fd_sc_hd__or4_1
X_3225_ clknet_leaf_12_clk _0061_ VGND VGND VPWR VPWR u_rx_fifo.mem\[10\]\[0\] sky130_fd_sc_hd__dfxtp_1
XFILLER_79_390 VGND VGND VPWR VPWR sky130_fd_sc_hd__fill_2
X_3156_ net433 u_uart_rx.vote_ones\[1\] _0704_ VGND VGND VPWR VPWR _0638_ sky130_fd_sc_hd__mux2_1
X_3087_ u_uart_rx.sample_div_count\[5\] u_uart_rx.sample_div_count\[6\] _1532_ _1542_
+ VGND VGND VPWR VPWR _1545_ sky130_fd_sc_hd__and4_1
XFILLER_27_449 VGND VGND VPWR VPWR sky130_fd_sc_hd__decap_4
X_2107_ _0977_ _0984_ VGND VGND VPWR VPWR _0985_ sky130_fd_sc_hd__xor2_4
XFILLER_36_29 VPWR VGND VPWR VGND sky130_ef_sc_hd__decap_12
XFILLER_54_224 VGND VGND VPWR VPWR sky130_fd_sc_hd__decap_3
Xclkbuf_leaf_19_clk clknet_3_5__leaf_clk VGND VGND VPWR VPWR clknet_leaf_19_clk sky130_fd_sc_hd__clkbuf_8
X_2038_ net19 net317 _0957_ VGND VGND VPWR VPWR _0147_ sky130_fd_sc_hd__mux2_1
XFILLER_42_419 VGND VGND VPWR VPWR sky130_fd_sc_hd__fill_1
XFILLER_35_471 VPWR VGND VPWR VGND sky130_ef_sc_hd__decap_12
XFILLER_22_165 VGND VGND VPWR VPWR sky130_fd_sc_hd__decap_4
XFILLER_50_474 VGND VGND VPWR VPWR sky130_fd_sc_hd__fill_2
XTAP_TAPCELL_ROW_20_388 VGND VPWR sky130_fd_sc_hd__tapvpwrvgnd_1
Xhold361 u_parser.u_packet_encoder.tag_latched\[38\] VGND VGND VPWR VPWR net517 sky130_fd_sc_hd__dlygate4sd3_1
Xhold350 tag_raw\[28\] VGND VGND VPWR VPWR net506 sky130_fd_sc_hd__dlygate4sd3_1
Xhold372 u_parser.u_packet_encoder.tag_latched\[19\] VGND VGND VPWR VPWR net528 sky130_fd_sc_hd__dlygate4sd3_1
Xhold394 u_parser.u_packet_encoder.tag_latched\[3\] VGND VGND VPWR VPWR net550 sky130_fd_sc_hd__dlygate4sd3_1
Xhold383 u_parser.u_packet_encoder.tag_latched\[21\] VGND VGND VPWR VPWR net539 sky130_fd_sc_hd__dlygate4sd3_1
XFILLER_93_57 VPWR VGND VPWR VGND sky130_ef_sc_hd__decap_12
XFILLER_85_393 VGND VGND VPWR VPWR sky130_fd_sc_hd__fill_2
XTAP_TAPCELL_ROW_56_731 VGND VPWR sky130_fd_sc_hd__tapvpwrvgnd_1
XFILLER_73_544 VGND VGND VPWR VPWR sky130_fd_sc_hd__decap_8
XTAP_TAPCELL_ROW_28_466 VGND VPWR sky130_fd_sc_hd__tapvpwrvgnd_1
XFILLER_45_268 VGND VGND VPWR VPWR sky130_fd_sc_hd__decap_4
XFILLER_45_279 VGND VGND VPWR VPWR sky130_fd_sc_hd__fill_1
XFILLER_13_110 VGND VGND VPWR VPWR sky130_fd_sc_hd__fill_2
XFILLER_41_496 VGND VGND VPWR VPWR sky130_fd_sc_hd__decap_8
XFILLER_9_169 VPWR VGND VPWR VGND sky130_ef_sc_hd__decap_12
XFILLER_42_83 VGND VGND VPWR VPWR sky130_fd_sc_hd__fill_1
X_3010_ net23 net304 _1505_ VGND VGND VPWR VPWR _0571_ sky130_fd_sc_hd__mux2_1
XFILLER_49_552 VGND VGND VPWR VPWR sky130_fd_sc_hd__decap_3
XFILLER_64_533 VPWR VGND VPWR VGND sky130_ef_sc_hd__decap_12
XTAP_TAPCELL_ROW_62_789 VGND VPWR sky130_fd_sc_hd__tapvpwrvgnd_1
X_3774_ clknet_leaf_17_clk _0592_ VGND VGND VPWR VPWR u_rx_fifo.mem\[2\]\[7\] sky130_fd_sc_hd__dfxtp_1
X_2725_ net41 u_parser.u_decoder.ascii_buf\[9\]\[0\] _1375_ VGND VGND VPWR VPWR _0416_
+ sky130_fd_sc_hd__mux2_1
X_2656_ _1200_ _1317_ VGND VGND VPWR VPWR _1339_ sky130_fd_sc_hd__xnor2_1
Xclkbuf_leaf_8_clk clknet_3_4__leaf_clk VGND VGND VPWR VPWR clknet_leaf_8_clk sky130_fd_sc_hd__clkbuf_8
X_1607_ u_parser.u_decoder.decoded_checksum_rx\[2\] VGND VGND VPWR VPWR _0677_ sky130_fd_sc_hd__inv_2
Xfanout104 net113 VGND VGND VPWR VPWR net104 sky130_fd_sc_hd__clkbuf_4
X_2587_ _1282_ _1285_ _0684_ VGND VGND VPWR VPWR _1286_ sky130_fd_sc_hd__mux2_1
Xfanout115 net116 VGND VGND VPWR VPWR net115 sky130_fd_sc_hd__clkbuf_4
Xfanout126 net157 VGND VGND VPWR VPWR net126 sky130_fd_sc_hd__buf_2
Xfanout137 net144 VGND VGND VPWR VPWR net137 sky130_fd_sc_hd__clkbuf_2
Xfanout148 u_rx_fifo.rd_ptr\[1\] VGND VGND VPWR VPWR net148 sky130_fd_sc_hd__buf_2
X_3208_ clknet_leaf_1_clk _0044_ VGND VGND VPWR VPWR u_tx_fifo.mem\[7\]\[7\] sky130_fd_sc_hd__dfxtp_1
XFILLER_47_39 VPWR VGND VPWR VGND sky130_ef_sc_hd__decap_12
X_3139_ u_uart_rx.bit_index\[1\] _0663_ VGND VGND VPWR VPWR _1574_ sky130_fd_sc_hd__nor2_1
XFILLER_70_503 VGND VGND VPWR VPWR sky130_fd_sc_hd__decap_6
XFILLER_27_279 VGND VGND VPWR VPWR sky130_fd_sc_hd__fill_1
XTAP_TAPCELL_ROW_53_701 VGND VPWR sky130_fd_sc_hd__tapvpwrvgnd_1
XFILLER_63_27 VPWR VGND VPWR VGND sky130_ef_sc_hd__decap_12
XTAP_TAPCELL_ROW_25_436 VGND VPWR sky130_fd_sc_hd__tapvpwrvgnd_1
XFILLER_42_249 VGND VGND VPWR VPWR sky130_fd_sc_hd__decap_3
XFILLER_10_102 VPWR VGND VPWR VGND sky130_ef_sc_hd__decap_12
XFILLER_10_135 VGND VGND VPWR VPWR sky130_fd_sc_hd__decap_4
Xhold180 u_rx_fifo.mem\[5\]\[7\] VGND VGND VPWR VPWR net336 sky130_fd_sc_hd__dlygate4sd3_1
XFILLER_5_3 VPWR VGND VPWR VGND sky130_ef_sc_hd__decap_12
XFILLER_77_113 VGND VGND VPWR VPWR sky130_fd_sc_hd__decap_8
XFILLER_2_389 VPWR VGND VPWR VGND sky130_ef_sc_hd__decap_12
Xhold191 u_tx_fifo.mem\[3\]\[2\] VGND VGND VPWR VPWR net347 sky130_fd_sc_hd__dlygate4sd3_1
XFILLER_18_224 VGND VGND VPWR VPWR sky130_fd_sc_hd__decap_4
XFILLER_46_522 VGND VGND VPWR VPWR sky130_fd_sc_hd__decap_4
XFILLER_18_235 VGND VGND VPWR VPWR sky130_fd_sc_hd__decap_4
X_3490_ clknet_leaf_36_clk _0317_ net131 VGND VGND VPWR VPWR u_parser.u_decoder.ascii_buf\[5\]\[4\]
+ sky130_fd_sc_hd__dfrtp_1
X_2510_ _1224_ VGND VGND VPWR VPWR _1225_ sky130_fd_sc_hd__inv_2
X_2441_ net4 _1171_ _1173_ VGND VGND VPWR VPWR _0334_ sky130_fd_sc_hd__and3_1
X_2372_ tag_raw\[25\] net492 net17 VGND VGND VPWR VPWR _0298_ sky130_fd_sc_hd__mux2_1
XFILLER_38_3 VPWR VGND VPWR VGND sky130_ef_sc_hd__decap_12
XTAP_TAPCELL_ROW_67_837 VGND VPWR sky130_fd_sc_hd__tapvpwrvgnd_1
XTAP_TAPCELL_ROW_22_406 VGND VPWR sky130_fd_sc_hd__tapvpwrvgnd_1
X_3826_ clknet_leaf_58_clk _0642_ VGND VGND VPWR VPWR u_tx_fifo.mem\[0\]\[3\] sky130_fd_sc_hd__dfxtp_1
XFILLER_20_477 VGND VGND VPWR VPWR sky130_fd_sc_hd__decap_3
X_3757_ clknet_leaf_66_clk _0575_ VGND VGND VPWR VPWR u_tx_fifo.mem\[15\]\[6\] sky130_fd_sc_hd__dfxtp_1
XTAP_TAPCELL_ROW_30_483 VGND VPWR sky130_fd_sc_hd__tapvpwrvgnd_1
X_2708_ net39 u_parser.u_decoder.ascii_buf\[10\]\[1\] _1373_ VGND VGND VPWR VPWR _0401_
+ sky130_fd_sc_hd__mux2_1
X_3688_ clknet_leaf_7_clk _0515_ VGND VGND VPWR VPWR u_tx_fifo.mem\[1\]\[6\] sky130_fd_sc_hd__dfxtp_1
X_2639_ u_parser.u_decoder.ascii_buf\[0\]\[3\] _1324_ _1325_ u_parser.u_decoder.ascii_buf\[0\]\[7\]
+ u_parser.u_decoder.ascii_buf\[0\]\[6\] VGND VGND VPWR VPWR _1326_ sky130_fd_sc_hd__a2111oi_1
XFILLER_58_27 VGND VGND VPWR VPWR sky130_fd_sc_hd__fill_1
XFILLER_87_455 VGND VGND VPWR VPWR sky130_fd_sc_hd__fill_1
XFILLER_87_488 VPWR VGND VPWR VGND sky130_ef_sc_hd__decap_12
XFILLER_28_533 VPWR VGND VPWR VGND sky130_ef_sc_hd__decap_12
XFILLER_74_15 VPWR VGND VPWR VGND sky130_ef_sc_hd__decap_12
XTAP_TAPCELL_ROW_38_561 VGND VPWR sky130_fd_sc_hd__tapvpwrvgnd_1
XFILLER_43_514 VGND VGND VPWR VPWR sky130_fd_sc_hd__decap_6
XFILLER_11_433 VPWR VGND VPWR VGND sky130_ef_sc_hd__decap_12
XFILLER_23_41 VGND VGND VPWR VPWR sky130_fd_sc_hd__decap_6
XTAP_TAPCELL_ROW_88_1039 VGND VPWR sky130_fd_sc_hd__tapvpwrvgnd_1
XTAP_TAPCELL_ROW_64_807 VGND VPWR sky130_fd_sc_hd__tapvpwrvgnd_1
XFILLER_34_525 VGND VGND VPWR VPWR sky130_fd_sc_hd__decap_6
X_2990_ _0828_ _0833_ VGND VGND VPWR VPWR _1499_ sky130_fd_sc_hd__nand2_1
XFILLER_64_92 VPWR VGND VPWR VGND sky130_ef_sc_hd__decap_12
XTAP_TAPCELL_ROW_72_884 VGND VPWR sky130_fd_sc_hd__tapvpwrvgnd_1
XFILLER_9_43 VGND VGND VPWR VPWR sky130_fd_sc_hd__fill_1
X_1941_ net357 net78 _0943_ VGND VGND VPWR VPWR _0064_ sky130_fd_sc_hd__mux2_1
X_1872_ u_parser.u_packet_encoder.byte_index\[2\] _0895_ u_parser.u_packet_encoder.byte_index\[3\]
+ VGND VGND VPWR VPWR _0902_ sky130_fd_sc_hd__nor3b_4
X_3611_ clknet_leaf_38_clk _0438_ net128 VGND VGND VPWR VPWR u_parser.u_decoder.decoded_checksum_rx\[6\]
+ sky130_fd_sc_hd__dfrtp_1
X_3542_ clknet_leaf_45_clk _0369_ net110 VGND VGND VPWR VPWR u_parser.u_decoder.decoded_payload\[25\]
+ sky130_fd_sc_hd__dfrtp_1
X_3473_ clknet_leaf_43_clk _0300_ net107 VGND VGND VPWR VPWR tag_raw\[27\] sky130_fd_sc_hd__dfrtp_2
X_2424_ u_parser.u_decoder.timeout_count\[3\] _0786_ _1152_ u_parser.u_decoder.timeout_count\[4\]
+ VGND VGND VPWR VPWR _1162_ sky130_fd_sc_hd__a31o_1
X_2355_ tag_raw\[8\] net438 net17 VGND VGND VPWR VPWR _0281_ sky130_fd_sc_hd__mux2_1
XFILLER_69_444 VGND VGND VPWR VPWR sky130_fd_sc_hd__decap_4
X_2286_ u_tx_fifo.mem\[4\]\[3\] u_tx_fifo.mem\[5\]\[3\] u_tx_fifo.mem\[6\]\[3\] u_tx_fifo.mem\[7\]\[3\]
+ net68 net64 VGND VGND VPWR VPWR _1093_ sky130_fd_sc_hd__mux4_1
XFILLER_25_525 VPWR VGND VPWR VGND sky130_ef_sc_hd__decap_12
XFILLER_37_363 VGND VGND VPWR VPWR sky130_fd_sc_hd__fill_2
XFILLER_37_385 VGND VGND VPWR VPWR sky130_fd_sc_hd__decap_6
XFILLER_71_119 VGND VGND VPWR VPWR sky130_fd_sc_hd__fill_1
XTAP_TAPCELL_ROW_35_531 VGND VPWR sky130_fd_sc_hd__tapvpwrvgnd_1
XFILLER_44_29 VPWR VGND VPWR VGND sky130_ef_sc_hd__decap_12
XFILLER_52_344 VPWR VGND VPWR VGND sky130_ef_sc_hd__decap_12
XFILLER_40_506 VGND VGND VPWR VPWR sky130_fd_sc_hd__decap_8
X_3809_ clknet_leaf_61_clk _0626_ net88 VGND VGND VPWR VPWR u_tx_fifo.rd_ptr\[1\]
+ sky130_fd_sc_hd__dfrtp_2
XFILLER_69_15 VPWR VGND VPWR VGND sky130_ef_sc_hd__decap_12
XTAP_TAPCELL_ROW_7_267 VGND VPWR sky130_fd_sc_hd__tapvpwrvgnd_1
XFILLER_47_105 VGND VGND VPWR VPWR sky130_fd_sc_hd__decap_6
XFILLER_47_149 VGND VGND VPWR VPWR sky130_fd_sc_hd__fill_2
XFILLER_75_447 VGND VGND VPWR VPWR sky130_fd_sc_hd__fill_1
XFILLER_43_333 VGND VGND VPWR VPWR sky130_fd_sc_hd__decap_3
XFILLER_70_141 VGND VGND VPWR VPWR sky130_fd_sc_hd__decap_3
XFILLER_7_223 VGND VGND VPWR VPWR sky130_fd_sc_hd__fill_1
XTAP_TAPCELL_ROW_41_589 VGND VPWR sky130_fd_sc_hd__tapvpwrvgnd_1
XFILLER_50_83 VGND VGND VPWR VPWR sky130_fd_sc_hd__fill_1
XFILLER_3_473 VPWR VGND VPWR VGND sky130_ef_sc_hd__decap_12
XFILLER_78_274 VGND VGND VPWR VPWR sky130_fd_sc_hd__decap_6
XTAP_TAPCELL_ROW_77_932 VGND VPWR sky130_fd_sc_hd__tapvpwrvgnd_1
X_2140_ _1010_ _1017_ VGND VGND VPWR VPWR _1018_ sky130_fd_sc_hd__xnor2_1
X_2071_ net23 net347 _0962_ VGND VGND VPWR VPWR _0175_ sky130_fd_sc_hd__mux2_1
XTAP_TAPCELL_ROW_49_667 VGND VPWR sky130_fd_sc_hd__tapvpwrvgnd_1
XFILLER_66_469 VGND VGND VPWR VPWR sky130_fd_sc_hd__decap_6
XFILLER_93_277 VGND VGND VPWR VPWR sky130_fd_sc_hd__decap_3
XFILLER_81_428 VGND VGND VPWR VPWR sky130_fd_sc_hd__decap_8
XFILLER_34_300 VGND VGND VPWR VPWR sky130_fd_sc_hd__decap_3
XFILLER_53_108 VGND VGND VPWR VPWR sky130_fd_sc_hd__decap_4
XFILLER_34_344 VGND VGND VPWR VPWR sky130_fd_sc_hd__decap_4
X_2973_ u_uart_rx.low_count\[13\] _0844_ _1492_ VGND VGND VPWR VPWR _1493_ sky130_fd_sc_hd__and3_1
XTAP_TAPCELL_ROW_32_501 VGND VPWR sky130_fd_sc_hd__tapvpwrvgnd_1
XFILLER_61_174 VPWR VGND VPWR VGND sky130_ef_sc_hd__decap_12
X_1924_ net255 net76 _0941_ VGND VGND VPWR VPWR _0049_ sky130_fd_sc_hd__mux2_1
X_1855_ net241 net77 _0888_ VGND VGND VPWR VPWR _0033_ sky130_fd_sc_hd__mux2_1
X_1786_ u_uart_rx.state\[4\] _0702_ VGND VGND VPWR VPWR _0001_ sky130_fd_sc_hd__and2_1
Xfanout6 _1441_ VGND VGND VPWR VPWR net6 sky130_fd_sc_hd__clkbuf_2
X_3525_ clknet_leaf_45_clk _0352_ net110 VGND VGND VPWR VPWR u_parser.u_decoder.decoded_payload\[8\]
+ sky130_fd_sc_hd__dfrtp_1
XFILLER_89_517 VPWR VGND VPWR VGND sky130_ef_sc_hd__decap_12
X_3456_ clknet_leaf_46_clk _0283_ net105 VGND VGND VPWR VPWR tag_raw\[10\] sky130_fd_sc_hd__dfrtp_1
X_3387_ clknet_leaf_52_clk _0220_ net98 VGND VGND VPWR VPWR u_parser.u_packet_encoder.tag_latched\[23\]
+ sky130_fd_sc_hd__dfrtp_1
X_2407_ u_parser.u_decoder.index\[2\] _0818_ _0963_ _1145_ u_parser.u_decoder.index\[3\]
+ VGND VGND VPWR VPWR _1150_ sky130_fd_sc_hd__a41o_1
X_2338_ net70 net343 _1132_ VGND VGND VPWR VPWR _0272_ sky130_fd_sc_hd__mux2_1
XTAP_TAPCELL_ROW_4_237 VGND VPWR sky130_fd_sc_hd__tapvpwrvgnd_1
X_2269_ _1076_ _1077_ net61 VGND VGND VPWR VPWR _1078_ sky130_fd_sc_hd__mux2_1
XFILLER_57_469 VGND VGND VPWR VPWR sky130_fd_sc_hd__decap_6
XFILLER_84_277 VGND VGND VPWR VPWR sky130_fd_sc_hd__decap_6
XFILLER_55_39 VPWR VGND VPWR VGND sky130_ef_sc_hd__decap_12
XFILLER_13_517 VPWR VGND VPWR VGND sky130_ef_sc_hd__decap_12
XFILLER_52_141 VPWR VGND VPWR VGND sky130_ef_sc_hd__decap_12
XFILLER_52_185 VGND VGND VPWR VPWR sky130_fd_sc_hd__decap_8
XFILLER_71_27 VPWR VGND VPWR VGND sky130_ef_sc_hd__decap_12
XFILLER_0_421 VPWR VGND VPWR VGND sky130_ef_sc_hd__decap_12
Xhold40 u_rx_fifo.mem\[0\]\[3\] VGND VGND VPWR VPWR net196 sky130_fd_sc_hd__dlygate4sd3_1
Xhold62 u_tx_fifo.mem\[14\]\[3\] VGND VGND VPWR VPWR net218 sky130_fd_sc_hd__dlygate4sd3_1
Xhold73 u_tx_fifo.mem\[10\]\[6\] VGND VGND VPWR VPWR net229 sky130_fd_sc_hd__dlygate4sd3_1
Xhold51 u_tx_fifo.mem\[0\]\[0\] VGND VGND VPWR VPWR net207 sky130_fd_sc_hd__dlygate4sd3_1
XTAP_TAPCELL_ROW_85_1009 VGND VPWR sky130_fd_sc_hd__tapvpwrvgnd_1
Xhold95 u_tx_fifo.mem\[15\]\[7\] VGND VGND VPWR VPWR net251 sky130_fd_sc_hd__dlygate4sd3_1
Xhold84 u_tx_fifo.mem\[13\]\[2\] VGND VGND VPWR VPWR net240 sky130_fd_sc_hd__dlygate4sd3_1
XTAP_TAPCELL_ROW_74_902 VGND VPWR sky130_fd_sc_hd__tapvpwrvgnd_1
XTAP_TAPCELL_ROW_46_637 VGND VPWR sky130_fd_sc_hd__tapvpwrvgnd_1
XFILLER_43_130 VPWR VGND VPWR VGND sky130_ef_sc_hd__decap_12
XFILLER_71_461 VGND VGND VPWR VPWR sky130_fd_sc_hd__decap_6
XFILLER_16_377 VPWR VGND VPWR VGND sky130_ef_sc_hd__decap_12
X_1640_ u_rx_fifo.level\[3\] _0706_ VGND VGND VPWR VPWR _0707_ sky130_fd_sc_hd__or2_1
X_3310_ clknet_leaf_65_clk _0146_ VGND VGND VPWR VPWR u_tx_fifo.mem\[13\]\[5\] sky130_fd_sc_hd__dfxtp_1
X_3241_ clknet_leaf_21_clk _0077_ VGND VGND VPWR VPWR u_rx_fifo.mem\[14\]\[0\] sky130_fd_sc_hd__dfxtp_1
X_3172_ net21 net268 _1586_ VGND VGND VPWR VPWR _0652_ sky130_fd_sc_hd__mux2_1
XFILLER_20_3 VPWR VGND VPWR VGND sky130_ef_sc_hd__decap_12
XTAP_TAPCELL_ROW_1_207 VGND VPWR sky130_fd_sc_hd__tapvpwrvgnd_1
X_2123_ _0974_ _1000_ VGND VGND VPWR VPWR _1001_ sky130_fd_sc_hd__xnor2_2
XFILLER_81_225 VGND VGND VPWR VPWR sky130_fd_sc_hd__fill_1
X_2054_ net266 net76 _0959_ VGND VGND VPWR VPWR _0161_ sky130_fd_sc_hd__mux2_1
XFILLER_34_141 VGND VGND VPWR VPWR sky130_fd_sc_hd__decap_8
XTAP_TAPCELL_ROW_17_361 VGND VPWR sky130_fd_sc_hd__tapvpwrvgnd_1
X_2956_ net648 _1480_ _1481_ VGND VGND VPWR VPWR _0541_ sky130_fd_sc_hd__o21a_1
X_1907_ u_parser.u_packet_encoder.crc_latched\[5\] _0904_ _0930_ _0931_ VGND VGND
+ VPWR VPWR _0932_ sky130_fd_sc_hd__o22a_1
X_2887_ net20 net417 _1438_ VGND VGND VPWR VPWR _0515_ sky130_fd_sc_hd__mux2_1
X_1838_ _0849_ u_rx_fifo.wr_ptr\[0\] u_rx_fifo.wr_ptr\[1\] VGND VGND VPWR VPWR _0884_
+ sky130_fd_sc_hd__or3b_4
X_1769_ u_tx_fifo.level\[1\] u_tx_fifo.level\[0\] u_tx_fifo.level\[3\] u_tx_fifo.level\[2\]
+ VGND VGND VPWR VPWR _0832_ sky130_fd_sc_hd__or4_1
X_3508_ clknet_leaf_33_clk _0335_ net140 VGND VGND VPWR VPWR u_parser.u_decoder.timeout_count\[10\]
+ sky130_fd_sc_hd__dfrtp_1
X_3439_ clknet_leaf_17_clk _0272_ VGND VGND VPWR VPWR u_rx_fifo.mem\[1\]\[7\] sky130_fd_sc_hd__dfxtp_1
XFILLER_66_27 VGND VGND VPWR VPWR sky130_fd_sc_hd__fill_1
XFILLER_85_553 VGND VGND VPWR VPWR sky130_fd_sc_hd__fill_2
XFILLER_57_277 VGND VGND VPWR VPWR sky130_fd_sc_hd__decap_3
XFILLER_38_491 VGND VGND VPWR VPWR sky130_fd_sc_hd__decap_8
XFILLER_45_428 VPWR VGND VPWR VGND sky130_ef_sc_hd__decap_12
XFILLER_82_15 VPWR VGND VPWR VGND sky130_ef_sc_hd__decap_12
XTAP_TAPCELL_ROW_43_607 VGND VPWR sky130_fd_sc_hd__tapvpwrvgnd_1
XFILLER_15_75 VGND VGND VPWR VPWR sky130_fd_sc_hd__fill_1
XTAP_TAPCELL_ROW_51_684 VGND VPWR sky130_fd_sc_hd__tapvpwrvgnd_1
XTAP_TAPCELL_ROW_91_1068 VGND VPWR sky130_fd_sc_hd__tapvpwrvgnd_1
XFILLER_76_553 VGND VGND VPWR VPWR sky130_fd_sc_hd__fill_2
XFILLER_76_531 VGND VGND VPWR VPWR sky130_fd_sc_hd__fill_1
XTAP_TAPCELL_ROW_59_762 VGND VPWR sky130_fd_sc_hd__tapvpwrvgnd_1
XFILLER_63_225 VPWR VGND VPWR VGND sky130_ef_sc_hd__decap_12
XFILLER_16_141 VGND VGND VPWR VPWR sky130_fd_sc_hd__fill_2
XFILLER_63_247 VGND VGND VPWR VPWR sky130_fd_sc_hd__fill_1
XTAP_TAPCELL_ROW_14_331 VGND VPWR sky130_fd_sc_hd__tapvpwrvgnd_1
X_3790_ clknet_leaf_28_clk _0608_ net138 VGND VGND VPWR VPWR u_uart_rx.sample_div_count\[10\]
+ sky130_fd_sc_hd__dfrtp_1
X_2810_ u_parser.u_decoder.ascii_buf\[3\]\[1\] net39 _1411_ VGND VGND VPWR VPWR _0465_
+ sky130_fd_sc_hd__mux2_1
X_2741_ net619 _1376_ VGND VGND VPWR VPWR _0431_ sky130_fd_sc_hd__and2_1
X_2672_ _1206_ _1264_ VGND VGND VPWR VPWR _1352_ sky130_fd_sc_hd__xnor2_1
XFILLER_68_3 VPWR VGND VPWR VGND sky130_ef_sc_hd__decap_12
X_1623_ u_uart_rx.sample_div_count\[8\] u_uart_rx.sample_div_count\[11\] u_uart_rx.sample_div_count\[10\]
+ u_uart_rx.sample_div_count\[9\] VGND VGND VPWR VPWR _0693_ sky130_fd_sc_hd__or4b_1
X_3224_ clknet_leaf_17_clk _0060_ VGND VGND VPWR VPWR u_rx_fifo.mem\[7\]\[7\] sky130_fd_sc_hd__dfxtp_1
.ends
